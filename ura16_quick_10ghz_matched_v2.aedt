# Ansys Electronics Desktop project, version 2023.1
materials:
  vacuum: permittivity=1
  air: permittivity=1.0006 permeability=1.0000004
  pec: conductivity=1e+30

design URA16_Quick_10GHz (HFSS, HFSS Hybrid Modal Network, model units mm)
variables:
  f0 = 10GHz
  lambda0 = 30mm
  spacing = 15mm
  dipole_length = 14.2mm
  interelement_tip_gap = 0.8mm
  array_nx = 16
  array_ny = 16
  max_active_ratio = 0.5
geometry:
  AirRegion [air] = box(corner=(-134.6mm, -134.6mm, -15mm), size=(269.2mm, 269.2mm, 30mm))
  Dipole_000_L [pec] = cylinder(axis=X, base_centre=(-119.6mm, -112.5mm, 0mm), radius=0.25mm, height=6.85mm, segments=12)
  Dipole_000_R [pec] = cylinder(axis=X, base_centre=(-112.25mm, -112.5mm, 0mm), radius=0.25mm, height=6.85mm, segments=12)
  PortSheet_000 = rectangle(corner=(-112.75mm, -112.5mm, -0.5mm), z_size=0.5mm, x_size=1mm)
  Dipole_001_L [pec] = cylinder(axis=X, base_centre=(-119.6mm, -97.5mm, 0mm), radius=0.25mm, height=6.85mm, segments=12)
  Dipole_001_R [pec] = cylinder(axis=X, base_centre=(-112.25mm, -97.5mm, 0mm), radius=0.25mm, height=6.85mm, segments=12)
  PortSheet_001 = rectangle(corner=(-112.75mm, -97.5mm, -0.5mm), z_size=0.5mm, x_size=1mm)
  Dipole_002_L [pec] = cylinder(axis=X, base_centre=(-119.6mm, -82.5mm, 0mm), radius=0.25mm, height=6.85mm, segments=12)
  Dipole_002_R [pec] = cylinder(axis=X, base_centre=(-112.25mm, -82.5mm, 0mm), radius=0.25mm, height=6.85mm, segments=12)
  PortSheet_002 = rectangle(corner=(-112.75mm, -82.5mm, -0.5mm), z_size=0.5mm, x_size=1mm)
  Dipole_003_L [pec] = cylinder(axis=X, base_centre=(-119.6mm, -67.5mm, 0mm), radius=0.25mm, height=6.85mm, segments=12)
  Dipole_003_R [pec] = cylinder(axis=X, base_centre=(-112.25mm, -67.5mm, 0mm), radius=0.25mm, height=6.85mm, segments=12)
  PortSheet_003 = rectangle(corner=(-112.75mm, -67.5mm, -0.5mm), z_size=0.5mm, x_size=1mm)
  Dipole_004_L [pec] = cylinder(axis=X, base_centre=(-119.6mm, -52.5mm, 0mm), radius=0.25mm, height=6.85mm, segments=12)
  Dipole_004_R [pec] = cylinder(axis=X, base_centre=(-112.25mm, -52.5mm, 0mm), radius=0.25mm, height=6.85mm, segments=12)
  PortSheet_004 = rectangle(corner=(-112.75mm, -52.5mm, -0.5mm), z_size=0.5mm, x_size=1mm)
  Dipole_005_L [pec] = cylinder(axis=X, base_centre=(-119.6mm, -37.5mm, 0mm), radius=0.25mm, height=6.85mm, segments=12)
  Dipole_005_R [pec] = cylinder(axis=X, base_centre=(-112.25mm, -37.5mm, 0mm), radius=0.25mm, height=6.85mm, segments=12)
  PortSheet_005 = rectangle(corner=(-112.75mm, -37.5mm, -0.5mm), z_size=0.5mm, x_size=1mm)
  Dipole_006_L [pec] = cylinder(axis=X, base_centre=(-119.6mm, -22.5mm, 0mm), radius=0.25mm, height=6.85mm, segments=12)
  Dipole_006_R [pec] = cylinder(axis=X, base_centre=(-112.25mm, -22.5mm, 0mm), radius=0.25mm, height=6.85mm, segments=12)
  PortSheet_006 = rectangle(corner=(-112.75mm, -22.5mm, -0.5mm), z_size=0.5mm, x_size=1mm)
  Dipole_007_L [pec] = cylinder(axis=X, base_centre=(-119.6mm, -7.5mm, 0mm), radius=0.25mm, height=6.85mm, segments=12)
  Dipole_007_R [pec] = cylinder(axis=X, base_centre=(-112.25mm, -7.5mm, 0mm), radius=0.25mm, height=6.85mm, segments=12)
  PortSheet_007 = rectangle(corner=(-112.75mm, -7.5mm, -0.5mm), z_size=0.5mm, x_size=1mm)
  Dipole_008_L [pec] = cylinder(axis=X, base_centre=(-119.6mm, 7.5mm, 0mm), radius=0.25mm, height=6.85mm, segments=12)
  Dipole_008_R [pec] = cylinder(axis=X, base_centre=(-112.25mm, 7.5mm, 0mm), radius=0.25mm, height=6.85mm, segments=12)
  PortSheet_008 = rectangle(corner=(-112.75mm, 7.5mm, -0.5mm), z_size=0.5mm, x_size=1mm)
  Dipole_009_L [pec] = cylinder(axis=X, base_centre=(-119.6mm, 22.5mm, 0mm), radius=0.25mm, height=6.85mm, segments=12)
  Dipole_009_R [pec] = cylinder(axis=X, base_centre=(-112.25mm, 22.5mm, 0mm), radius=0.25mm, height=6.85mm, segments=12)
  PortSheet_009 = rectangle(corner=(-112.75mm, 22.5mm, -0.5mm), z_size=0.5mm, x_size=1mm)
  Dipole_010_L [pec] = cylinder(axis=X, base_centre=(-119.6mm, 37.5mm, 0mm), radius=0.25mm, height=6.85mm, segments=12)
  Dipole_010_R [pec] = cylinder(axis=X, base_centre=(-112.25mm, 37.5mm, 0mm), radius=0.25mm, height=6.85mm, segments=12)
  PortSheet_010 = rectangle(corner=(-112.75mm, 37.5mm, -0.5mm), z_size=0.5mm, x_size=1mm)
  Dipole_011_L [pec] = cylinder(axis=X, base_centre=(-119.6mm, 52.5mm, 0mm), radius=0.25mm, height=6.85mm, segments=12)
  Dipole_011_R [pec] = cylinder(axis=X, base_centre=(-112.25mm, 52.5mm, 0mm), radius=0.25mm, height=6.85mm, segments=12)
  PortSheet_011 = rectangle(corner=(-112.75mm, 52.5mm, -0.5mm), z_size=0.5mm, x_size=1mm)
  Dipole_012_L [pec] = cylinder(axis=X, base_centre=(-119.6mm, 67.5mm, 0mm), radius=0.25mm, height=6.85mm, segments=12)
  Dipole_012_R [pec] = cylinder(axis=X, base_centre=(-112.25mm, 67.5mm, 0mm), radius=0.25mm, height=6.85mm, segments=12)
  PortSheet_012 = rectangle(corner=(-112.75mm, 67.5mm, -0.5mm), z_size=0.5mm, x_size=1mm)
  Dipole_013_L [pec] = cylinder(axis=X, base_centre=(-119.6mm, 82.5mm, 0mm), radius=0.25mm, height=6.85mm, segments=12)
  Dipole_013_R [pec] = cylinder(axis=X, base_centre=(-112.25mm, 82.5mm, 0mm), radius=0.25mm, height=6.85mm, segments=12)
  PortSheet_013 = rectangle(corner=(-112.75mm, 82.5mm, -0.5mm), z_size=0.5mm, x_size=1mm)
  Dipole_014_L [pec] = cylinder(axis=X, base_centre=(-119.6mm, 97.5mm, 0mm), radius=0.25mm, height=6.85mm, segments=12)
  Dipole_014_R [pec] = cylinder(axis=X, base_centre=(-112.25mm, 97.5mm, 0mm), radius=0.25mm, height=6.85mm, segments=12)
  PortSheet_014 = rectangle(corner=(-112.75mm, 97.5mm, -0.5mm), z_size=0.5mm, x_size=1mm)
  Dipole_015_L [pec] = cylinder(axis=X, base_centre=(-119.6mm, 112.5mm, 0mm), radius=0.25mm, height=6.85mm, segments=12)
  Dipole_015_R [pec] = cylinder(axis=X, base_centre=(-112.25mm, 112.5mm, 0mm), radius=0.25mm, height=6.85mm, segments=12)
  PortSheet_015 = rectangle(corner=(-112.75mm, 112.5mm, -0.5mm), z_size=0.5mm, x_size=1mm)
  Dipole_016_L [pec] = cylinder(axis=X, base_centre=(-104.6mm, -112.5mm, 0mm), radius=0.25mm, height=6.85mm, segments=12)
  Dipole_016_R [pec] = cylinder(axis=X, base_centre=(-97.25mm, -112.5mm, 0mm), radius=0.25mm, height=6.85mm, segments=12)
  PortSheet_016 = rectangle(corner=(-97.75mm, -112.5mm, -0.5mm), z_size=0.5mm, x_size=1mm)
  Dipole_017_L [pec] = cylinder(axis=X, base_centre=(-104.6mm, -97.5mm, 0mm), radius=0.25mm, height=6.85mm, segments=12)
  Dipole_017_R [pec] = cylinder(axis=X, base_centre=(-97.25mm, -97.5mm, 0mm), radius=0.25mm, height=6.85mm, segments=12)
  PortSheet_017 = rectangle(corner=(-97.75mm, -97.5mm, -0.5mm), z_size=0.5mm, x_size=1mm)
  Dipole_018_L [pec] = cylinder(axis=X, base_centre=(-104.6mm, -82.5mm, 0mm), radius=0.25mm, height=6.85mm, segments=12)
  Dipole_018_R [pec] = cylinder(axis=X, base_centre=(-97.25mm, -82.5mm, 0mm), radius=0.25mm, height=6.85mm, segments=12)
  PortSheet_018 = rectangle(corner=(-97.75mm, -82.5mm, -0.5mm), z_size=0.5mm, x_size=1mm)
  Dipole_019_L [pec] = cylinder(axis=X, base_centre=(-104.6mm, -67.5mm, 0mm), radius=0.25mm, height=6.85mm, segments=12)
  Dipole_019_R [pec] = cylinder(axis=X, base_centre=(-97.25mm, -67.5mm, 0mm), radius=0.25mm, height=6.85mm, segments=12)
  PortSheet_019 = rectangle(corner=(-97.75mm, -67.5mm, -0.5mm), z_size=0.5mm, x_size=1mm)
  Dipole_020_L [pec] = cylinder(axis=X, base_centre=(-104.6mm, -52.5mm, 0mm), radius=0.25mm, height=6.85mm, segments=12)
  Dipole_020_R [pec] = cylinder(axis=X, base_centre=(-97.25mm, -52.5mm, 0mm), radius=0.25mm, height=6.85mm, segments=12)
  PortSheet_020 = rectangle(corner=(-97.75mm, -52.5mm, -0.5mm), z_size=0.5mm, x_size=1mm)
  Dipole_021_L [pec] = cylinder(axis=X, base_centre=(-104.6mm, -37.5mm, 0mm), radius=0.25mm, height=6.85mm, segments=12)
  Dipole_021_R [pec] = cylinder(axis=X, base_centre=(-97.25mm, -37.5mm, 0mm), radius=0.25mm, height=6.85mm, segments=12)
  PortSheet_021 = rectangle(corner=(-97.75mm, -37.5mm, -0.5mm), z_size=0.5mm, x_size=1mm)
  Dipole_022_L [pec] = cylinder(axis=X, base_centre=(-104.6mm, -22.5mm, 0mm), radius=0.25mm, height=6.85mm, segments=12)
  Dipole_022_R [pec] = cylinder(axis=X, base_centre=(-97.25mm, -22.5mm, 0mm), radius=0.25mm, height=6.85mm, segments=12)
  PortSheet_022 = rectangle(corner=(-97.75mm, -22.5mm, -0.5mm), z_size=0.5mm, x_size=1mm)
  Dipole_023_L [pec] = cylinder(axis=X, base_centre=(-104.6mm, -7.5mm, 0mm), radius=0.25mm, height=6.85mm, segments=12)
  Dipole_023_R [pec] = cylinder(axis=X, base_centre=(-97.25mm, -7.5mm, 0mm), radius=0.25mm, height=6.85mm, segments=12)
  PortSheet_023 = rectangle(corner=(-97.75mm, -7.5mm, -0.5mm), z_size=0.5mm, x_size=1mm)
  Dipole_024_L [pec] = cylinder(axis=X, base_centre=(-104.6mm, 7.5mm, 0mm), radius=0.25mm, height=6.85mm, segments=12)
  Dipole_024_R [pec] = cylinder(axis=X, base_centre=(-97.25mm, 7.5mm, 0mm), radius=0.25mm, height=6.85mm, segments=12)
  PortSheet_024 = rectangle(corner=(-97.75mm, 7.5mm, -0.5mm), z_size=0.5mm, x_size=1mm)
  Dipole_025_L [pec] = cylinder(axis=X, base_centre=(-104.6mm, 22.5mm, 0mm), radius=0.25mm, height=6.85mm, segments=12)
  Dipole_025_R [pec] = cylinder(axis=X, base_centre=(-97.25mm, 22.5mm, 0mm), radius=0.25mm, height=6.85mm, segments=12)
  PortSheet_025 = rectangle(corner=(-97.75mm, 22.5mm, -0.5mm), z_size=0.5mm, x_size=1mm)
  Dipole_026_L [pec] = cylinder(axis=X, base_centre=(-104.6mm, 37.5mm, 0mm), radius=0.25mm, height=6.85mm, segments=12)
  Dipole_026_R [pec] = cylinder(axis=X, base_centre=(-97.25mm, 37.5mm, 0mm), radius=0.25mm, height=6.85mm, segments=12)
  PortSheet_026 = rectangle(corner=(-97.75mm, 37.5mm, -0.5mm), z_size=0.5mm, x_size=1mm)
  Dipole_027_L [pec] = cylinder(axis=X, base_centre=(-104.6mm, 52.5mm, 0mm), radius=0.25mm, height=6.85mm, segments=12)
  Dipole_027_R [pec] = cylinder(axis=X, base_centre=(-97.25mm, 52.5mm, 0mm), radius=0.25mm, height=6.85mm, segments=12)
  PortSheet_027 = rectangle(corner=(-97.75mm, 52.5mm, -0.5mm), z_size=0.5mm, x_size=1mm)
  Dipole_028_L [pec] = cylinder(axis=X, base_centre=(-104.6mm, 67.5mm, 0mm), radius=0.25mm, height=6.85mm, segments=12)
  Dipole_028_R [pec] = cylinder(axis=X, base_centre=(-97.25mm, 67.5mm, 0mm), radius=0.25mm, height=6.85mm, segments=12)
  PortSheet_028 = rectangle(corner=(-97.75mm, 67.5mm, -0.5mm), z_size=0.5mm, x_size=1mm)
  Dipole_029_L [pec] = cylinder(axis=X, base_centre=(-104.6mm, 82.5mm, 0mm), radius=0.25mm, height=6.85mm, segments=12)
  Dipole_029_R [pec] = cylinder(axis=X, base_centre=(-97.25mm, 82.5mm, 0mm), radius=0.25mm, height=6.85mm, segments=12)
  PortSheet_029 = rectangle(corner=(-97.75mm, 82.5mm, -0.5mm), z_size=0.5mm, x_size=1mm)
  Dipole_030_L [pec] = cylinder(axis=X, base_centre=(-104.6mm, 97.5mm, 0mm), radius=0.25mm, height=6.85mm, segments=12)
  Dipole_030_R [pec] = cylinder(axis=X, base_centre=(-97.25mm, 97.5mm, 0mm), radius=0.25mm, height=6.85mm, segments=12)
  PortSheet_030 = rectangle(corner=(-97.75mm, 97.5mm, -0.5mm), z_size=0.5mm, x_size=1mm)
  Dipole_031_L [pec] = cylinder(axis=X, base_centre=(-104.6mm, 112.5mm, 0mm), radius=0.25mm, height=6.85mm, segments=12)
  Dipole_031_R [pec] = cylinder(axis=X, base_centre=(-97.25mm, 112.5mm, 0mm), radius=0.25mm, height=6.85mm, segments=12)
  PortSheet_031 = rectangle(corner=(-97.75mm, 112.5mm, -0.5mm), z_size=0.5mm, x_size=1mm)
  Dipole_032_L [pec] = cylinder(axis=X, base_centre=(-89.6mm, -112.5mm, 0mm), radius=0.25mm, height=6.85mm, segments=12)
  Dipole_032_R [pec] = cylinder(axis=X, base_centre=(-82.25mm, -112.5mm, 0mm), radius=0.25mm, height=6.85mm, segments=12)
  PortSheet_032 = rectangle(corner=(-82.75mm, -112.5mm, -0.5mm), z_size=0.5mm, x_size=1mm)
  Dipole_033_L [pec] = cylinder(axis=X, base_centre=(-89.6mm, -97.5mm, 0mm), radius=0.25mm, height=6.85mm, segments=12)
  Dipole_033_R [pec] = cylinder(axis=X, base_centre=(-82.25mm, -97.5mm, 0mm), radius=0.25mm, height=6.85mm, segments=12)
  PortSheet_033 = rectangle(corner=(-82.75mm, -97.5mm, -0.5mm), z_size=0.5mm, x_size=1mm)
  Dipole_034_L [pec] = cylinder(axis=X, base_centre=(-89.6mm, -82.5mm, 0mm), radius=0.25mm, height=6.85mm, segments=12)
  Dipole_034_R [pec] = cylinder(axis=X, base_centre=(-82.25mm, -82.5mm, 0mm), radius=0.25mm, height=6.85mm, segments=12)
  PortSheet_034 = rectangle(corner=(-82.75mm, -82.5mm, -0.5mm), z_size=0.5mm, x_size=1mm)
  Dipole_035_L [pec] = cylinder(axis=X, base_centre=(-89.6mm, -67.5mm, 0mm), radius=0.25mm, height=6.85mm, segments=12)
  Dipole_035_R [pec] = cylinder(axis=X, base_centre=(-82.25mm, -67.5mm, 0mm), radius=0.25mm, height=6.85mm, segments=12)
  PortSheet_035 = rectangle(corner=(-82.75mm, -67.5mm, -0.5mm), z_size=0.5mm, x_size=1mm)
  Dipole_036_L [pec] = cylinder(axis=X, base_centre=(-89.6mm, -52.5mm, 0mm), radius=0.25mm, height=6.85mm, segments=12)
  Dipole_036_R [pec] = cylinder(axis=X, base_centre=(-82.25mm, -52.5mm, 0mm), radius=0.25mm, height=6.85mm, segments=12)
  PortSheet_036 = rectangle(corner=(-82.75mm, -52.5mm, -0.5mm), z_size=0.5mm, x_size=1mm)
  Dipole_037_L [pec] = cylinder(axis=X, base_centre=(-89.6mm, -37.5mm, 0mm), radius=0.25mm, height=6.85mm, segments=12)
  Dipole_037_R [pec] = cylinder(axis=X, base_centre=(-82.25mm, -37.5mm, 0mm), radius=0.25mm, height=6.85mm, segments=12)
  PortSheet_037 = rectangle(corner=(-82.75mm, -37.5mm, -0.5mm), z_size=0.5mm, x_size=1mm)
  Dipole_038_L [pec] = cylinder(axis=X, base_centre=(-89.6mm, -22.5mm, 0mm), radius=0.25mm, height=6.85mm, segments=12)
  Dipole_038_R [pec] = cylinder(axis=X, base_centre=(-82.25mm, -22.5mm, 0mm), radius=0.25mm, height=6.85mm, segments=12)
  PortSheet_038 = rectangle(corner=(-82.75mm, -22.5mm, -0.5mm), z_size=0.5mm, x_size=1mm)
  Dipole_039_L [pec] = cylinder(axis=X, base_centre=(-89.6mm, -7.5mm, 0mm), radius=0.25mm, height=6.85mm, segments=12)
  Dipole_039_R [pec] = cylinder(axis=X, base_centre=(-82.25mm, -7.5mm, 0mm), radius=0.25mm, height=6.85mm, segments=12)
  PortSheet_039 = rectangle(corner=(-82.75mm, -7.5mm, -0.5mm), z_size=0.5mm, x_size=1mm)
  Dipole_040_L [pec] = cylinder(axis=X, base_centre=(-89.6mm, 7.5mm, 0mm), radius=0.25mm, height=6.85mm, segments=12)
  Dipole_040_R [pec] = cylinder(axis=X, base_centre=(-82.25mm, 7.5mm, 0mm), radius=0.25mm, height=6.85mm, segments=12)
  PortSheet_040 = rectangle(corner=(-82.75mm, 7.5mm, -0.5mm), z_size=0.5mm, x_size=1mm)
  Dipole_041_L [pec] = cylinder(axis=X, base_centre=(-89.6mm, 22.5mm, 0mm), radius=0.25mm, height=6.85mm, segments=12)
  Dipole_041_R [pec] = cylinder(axis=X, base_centre=(-82.25mm, 22.5mm, 0mm), radius=0.25mm, height=6.85mm, segments=12)
  PortSheet_041 = rectangle(corner=(-82.75mm, 22.5mm, -0.5mm), z_size=0.5mm, x_size=1mm)
  Dipole_042_L [pec] = cylinder(axis=X, base_centre=(-89.6mm, 37.5mm, 0mm), radius=0.25mm, height=6.85mm, segments=12)
  Dipole_042_R [pec] = cylinder(axis=X, base_centre=(-82.25mm, 37.5mm, 0mm), radius=0.25mm, height=6.85mm, segments=12)
  PortSheet_042 = rectangle(corner=(-82.75mm, 37.5mm, -0.5mm), z_size=0.5mm, x_size=1mm)
  Dipole_043_L [pec] = cylinder(axis=X, base_centre=(-89.6mm, 52.5mm, 0mm), radius=0.25mm, height=6.85mm, segments=12)
  Dipole_043_R [pec] = cylinder(axis=X, base_centre=(-82.25mm, 52.5mm, 0mm), radius=0.25mm, height=6.85mm, segments=12)
  PortSheet_043 = rectangle(corner=(-82.75mm, 52.5mm, -0.5mm), z_size=0.5mm, x_size=1mm)
  Dipole_044_L [pec] = cylinder(axis=X, base_centre=(-89.6mm, 67.5mm, 0mm), radius=0.25mm, height=6.85mm, segments=12)
  Dipole_044_R [pec] = cylinder(axis=X, base_centre=(-82.25mm, 67.5mm, 0mm), radius=0.25mm, height=6.85mm, segments=12)
  PortSheet_044 = rectangle(corner=(-82.75mm, 67.5mm, -0.5mm), z_size=0.5mm, x_size=1mm)
  Dipole_045_L [pec] = cylinder(axis=X, base_centre=(-89.6mm, 82.5mm, 0mm), radius=0.25mm, height=6.85mm, segments=12)
  Dipole_045_R [pec] = cylinder(axis=X, base_centre=(-82.25mm, 82.5mm, 0mm), radius=0.25mm, height=6.85mm, segments=12)
  PortSheet_045 = rectangle(corner=(-82.75mm, 82.5mm, -0.5mm), z_size=0.5mm, x_size=1mm)
  Dipole_046_L [pec] = cylinder(axis=X, base_centre=(-89.6mm, 97.5mm, 0mm), radius=0.25mm, height=6.85mm, segments=12)
  Dipole_046_R [pec] = cylinder(axis=X, base_centre=(-82.25mm, 97.5mm, 0mm), radius=0.25mm, height=6.85mm, segments=12)
  PortSheet_046 = rectangle(corner=(-82.75mm, 97.5mm, -0.5mm), z_size=0.5mm, x_size=1mm)
  Dipole_047_L [pec] = cylinder(axis=X, base_centre=(-89.6mm, 112.5mm, 0mm), radius=0.25mm, height=6.85mm, segments=12)
  Dipole_047_R [pec] = cylinder(axis=X, base_centre=(-82.25mm, 112.5mm, 0mm), radius=0.25mm, height=6.85mm, segments=12)
  PortSheet_047 = rectangle(corner=(-82.75mm, 112.5mm, -0.5mm), z_size=0.5mm, x_size=1mm)
  Dipole_048_L [pec] = cylinder(axis=X, base_centre=(-74.6mm, -112.5mm, 0mm), radius=0.25mm, height=6.85mm, segments=12)
  Dipole_048_R [pec] = cylinder(axis=X, base_centre=(-67.25mm, -112.5mm, 0mm), radius=0.25mm, height=6.85mm, segments=12)
  PortSheet_048 = rectangle(corner=(-67.75mm, -112.5mm, -0.5mm), z_size=0.5mm, x_size=1mm)
  Dipole_049_L [pec] = cylinder(axis=X, base_centre=(-74.6mm, -97.5mm, 0mm), radius=0.25mm, height=6.85mm, segments=12)
  Dipole_049_R [pec] = cylinder(axis=X, base_centre=(-67.25mm, -97.5mm, 0mm), radius=0.25mm, height=6.85mm, segments=12)
  PortSheet_049 = rectangle(corner=(-67.75mm, -97.5mm, -0.5mm), z_size=0.5mm, x_size=1mm)
  Dipole_050_L [pec] = cylinder(axis=X, base_centre=(-74.6mm, -82.5mm, 0mm), radius=0.25mm, height=6.85mm, segments=12)
  Dipole_050_R [pec] = cylinder(axis=X, base_centre=(-67.25mm, -82.5mm, 0mm), radius=0.25mm, height=6.85mm, segments=12)
  PortSheet_050 = rectangle(corner=(-67.75mm, -82.5mm, -0.5mm), z_size=0.5mm, x_size=1mm)
  Dipole_051_L [pec] = cylinder(axis=X, base_centre=(-74.6mm, -67.5mm, 0mm), radius=0.25mm, height=6.85mm, segments=12)
  Dipole_051_R [pec] = cylinder(axis=X, base_centre=(-67.25mm, -67.5mm, 0mm), radius=0.25mm, height=6.85mm, segments=12)
  PortSheet_051 = rectangle(corner=(-67.75mm, -67.5mm, -0.5mm), z_size=0.5mm, x_size=1mm)
  Dipole_052_L [pec] = cylinder(axis=X, base_centre=(-74.6mm, -52.5mm, 0mm), radius=0.25mm, height=6.85mm, segments=12)
  Dipole_052_R [pec] = cylinder(axis=X, base_centre=(-67.25mm, -52.5mm, 0mm), radius=0.25mm, height=6.85mm, segments=12)
  PortSheet_052 = rectangle(corner=(-67.75mm, -52.5mm, -0.5mm), z_size=0.5mm, x_size=1mm)
  Dipole_053_L [pec] = cylinder(axis=X, base_centre=(-74.6mm, -37.5mm, 0mm), radius=0.25mm, height=6.85mm, segments=12)
  Dipole_053_R [pec] = cylinder(axis=X, base_centre=(-67.25mm, -37.5mm, 0mm), radius=0.25mm, height=6.85mm, segments=12)
  PortSheet_053 = rectangle(corner=(-67.75mm, -37.5mm, -0.5mm), z_size=0.5mm, x_size=1mm)
  Dipole_054_L [pec] = cylinder(axis=X, base_centre=(-74.6mm, -22.5mm, 0mm), radius=0.25mm, height=6.85mm, segments=12)
  Dipole_054_R [pec] = cylinder(axis=X, base_centre=(-67.25mm, -22.5mm, 0mm), radius=0.25mm, height=6.85mm, segments=12)
  PortSheet_054 = rectangle(corner=(-67.75mm, -22.5mm, -0.5mm), z_size=0.5mm, x_size=1mm)
  Dipole_055_L [pec] = cylinder(axis=X, base_centre=(-74.6mm, -7.5mm, 0mm), radius=0.25mm, height=6.85mm, segments=12)
  Dipole_055_R [pec] = cylinder(axis=X, base_centre=(-67.25mm, -7.5mm, 0mm), radius=0.25mm, height=6.85mm, segments=12)
  PortSheet_055 = rectangle(corner=(-67.75mm, -7.5mm, -0.5mm), z_size=0.5mm, x_size=1mm)
  Dipole_056_L [pec] = cylinder(axis=X, base_centre=(-74.6mm, 7.5mm, 0mm), radius=0.25mm, height=6.85mm, segments=12)
  Dipole_056_R [pec] = cylinder(axis=X, base_centre=(-67.25mm, 7.5mm, 0mm), radius=0.25mm, height=6.85mm, segments=12)
  PortSheet_056 = rectangle(corner=(-67.75mm, 7.5mm, -0.5mm), z_size=0.5mm, x_size=1mm)
  Dipole_057_L [pec] = cylinder(axis=X, base_centre=(-74.6mm, 22.5mm, 0mm), radius=0.25mm, height=6.85mm, segments=12)
  Dipole_057_R [pec] = cylinder(axis=X, base_centre=(-67.25mm, 22.5mm, 0mm), radius=0.25mm, height=6.85mm, segments=12)
  PortSheet_057 = rectangle(corner=(-67.75mm, 22.5mm, -0.5mm), z_size=0.5mm, x_size=1mm)
  Dipole_058_L [pec] = cylinder(axis=X, base_centre=(-74.6mm, 37.5mm, 0mm), radius=0.25mm, height=6.85mm, segments=12)
  Dipole_058_R [pec] = cylinder(axis=X, base_centre=(-67.25mm, 37.5mm, 0mm), radius=0.25mm, height=6.85mm, segments=12)
  PortSheet_058 = rectangle(corner=(-67.75mm, 37.5mm, -0.5mm), z_size=0.5mm, x_size=1mm)
  Dipole_059_L [pec] = cylinder(axis=X, base_centre=(-74.6mm, 52.5mm, 0mm), radius=0.25mm, height=6.85mm, segments=12)
  Dipole_059_R [pec] = cylinder(axis=X, base_centre=(-67.25mm, 52.5mm, 0mm), radius=0.25mm, height=6.85mm, segments=12)
  PortSheet_059 = rectangle(corner=(-67.75mm, 52.5mm, -0.5mm), z_size=0.5mm, x_size=1mm)
  Dipole_060_L [pec] = cylinder(axis=X, base_centre=(-74.6mm, 67.5mm, 0mm), radius=0.25mm, height=6.85mm, segments=12)
  Dipole_060_R [pec] = cylinder(axis=X, base_centre=(-67.25mm, 67.5mm, 0mm), radius=0.25mm, height=6.85mm, segments=12)
  PortSheet_060 = rectangle(corner=(-67.75mm, 67.5mm, -0.5mm), z_size=0.5mm, x_size=1mm)
  Dipole_061_L [pec] = cylinder(axis=X, base_centre=(-74.6mm, 82.5mm, 0mm), radius=0.25mm, height=6.85mm, segments=12)
  Dipole_061_R [pec] = cylinder(axis=X, base_centre=(-67.25mm, 82.5mm, 0mm), radius=0.25mm, height=6.85mm, segments=12)
  PortSheet_061 = rectangle(corner=(-67.75mm, 82.5mm, -0.5mm), z_size=0.5mm, x_size=1mm)
  Dipole_062_L [pec] = cylinder(axis=X, base_centre=(-74.6mm, 97.5mm, 0mm), radius=0.25mm, height=6.85mm, segments=12)
  Dipole_062_R [pec] = cylinder(axis=X, base_centre=(-67.25mm, 97.5mm, 0mm), radius=0.25mm, height=6.85mm, segments=12)
  PortSheet_062 = rectangle(corner=(-67.75mm, 97.5mm, -0.5mm), z_size=0.5mm, x_size=1mm)
  Dipole_063_L [pec] = cylinder(axis=X, base_centre=(-74.6mm, 112.5mm, 0mm), radius=0.25mm, height=6.85mm, segments=12)
  Dipole_063_R [pec] = cylinder(axis=X, base_centre=(-67.25mm, 112.5mm, 0mm), radius=0.25mm, height=6.85mm, segments=12)
  PortSheet_063 = rectangle(corner=(-67.75mm, 112.5mm, -0.5mm), z_size=0.5mm, x_size=1mm)
  Dipole_064_L [pec] = cylinder(axis=X, base_centre=(-59.6mm, -112.5mm, 0mm), radius=0.25mm, height=6.85mm, segments=12)
  Dipole_064_R [pec] = cylinder(axis=X, base_centre=(-52.25mm, -112.5mm, 0mm), radius=0.25mm, height=6.85mm, segments=12)
  PortSheet_064 = rectangle(corner=(-52.75mm, -112.5mm, -0.5mm), z_size=0.5mm, x_size=1mm)
  Dipole_065_L [pec] = cylinder(axis=X, base_centre=(-59.6mm, -97.5mm, 0mm), radius=0.25mm, height=6.85mm, segments=12)
  Dipole_065_R [pec] = cylinder(axis=X, base_centre=(-52.25mm, -97.5mm, 0mm), radius=0.25mm, height=6.85mm, segments=12)
  PortSheet_065 = rectangle(corner=(-52.75mm, -97.5mm, -0.5mm), z_size=0.5mm, x_size=1mm)
  Dipole_066_L [pec] = cylinder(axis=X, base_centre=(-59.6mm, -82.5mm, 0mm), radius=0.25mm, height=6.85mm, segments=12)
  Dipole_066_R [pec] = cylinder(axis=X, base_centre=(-52.25mm, -82.5mm, 0mm), radius=0.25mm, height=6.85mm, segments=12)
  PortSheet_066 = rectangle(corner=(-52.75mm, -82.5mm, -0.5mm), z_size=0.5mm, x_size=1mm)
  Dipole_067_L [pec] = cylinder(axis=X, base_centre=(-59.6mm, -67.5mm, 0mm), radius=0.25mm, height=6.85mm, segments=12)
  Dipole_067_R [pec] = cylinder(axis=X, base_centre=(-52.25mm, -67.5mm, 0mm), radius=0.25mm, height=6.85mm, segments=12)
  PortSheet_067 = rectangle(corner=(-52.75mm, -67.5mm, -0.5mm), z_size=0.5mm, x_size=1mm)
  Dipole_068_L [pec] = cylinder(axis=X, base_centre=(-59.6mm, -52.5mm, 0mm), radius=0.25mm, height=6.85mm, segments=12)
  Dipole_068_R [pec] = cylinder(axis=X, base_centre=(-52.25mm, -52.5mm, 0mm), radius=0.25mm, height=6.85mm, segments=12)
  PortSheet_068 = rectangle(corner=(-52.75mm, -52.5mm, -0.5mm), z_size=0.5mm, x_size=1mm)
  Dipole_069_L [pec] = cylinder(axis=X, base_centre=(-59.6mm, -37.5mm, 0mm), radius=0.25mm, height=6.85mm, segments=12)
  Dipole_069_R [pec] = cylinder(axis=X, base_centre=(-52.25mm, -37.5mm, 0mm), radius=0.25mm, height=6.85mm, segments=12)
  PortSheet_069 = rectangle(corner=(-52.75mm, -37.5mm, -0.5mm), z_size=0.5mm, x_size=1mm)
  Dipole_070_L [pec] = cylinder(axis=X, base_centre=(-59.6mm, -22.5mm, 0mm), radius=0.25mm, height=6.85mm, segments=12)
  Dipole_070_R [pec] = cylinder(axis=X, base_centre=(-52.25mm, -22.5mm, 0mm), radius=0.25mm, height=6.85mm, segments=12)
  PortSheet_070 = rectangle(corner=(-52.75mm, -22.5mm, -0.5mm), z_size=0.5mm, x_size=1mm)
  Dipole_071_L [pec] = cylinder(axis=X, base_centre=(-59.6mm, -7.5mm, 0mm), radius=0.25mm, height=6.85mm, segments=12)
  Dipole_071_R [pec] = cylinder(axis=X, base_centre=(-52.25mm, -7.5mm, 0mm), radius=0.25mm, height=6.85mm, segments=12)
  PortSheet_071 = rectangle(corner=(-52.75mm, -7.5mm, -0.5mm), z_size=0.5mm, x_size=1mm)
  Dipole_072_L [pec] = cylinder(axis=X, base_centre=(-59.6mm, 7.5mm, 0mm), radius=0.25mm, height=6.85mm, segments=12)
  Dipole_072_R [pec] = cylinder(axis=X, base_centre=(-52.25mm, 7.5mm, 0mm), radius=0.25mm, height=6.85mm, segments=12)
  PortSheet_072 = rectangle(corner=(-52.75mm, 7.5mm, -0.5mm), z_size=0.5mm, x_size=1mm)
  Dipole_073_L [pec] = cylinder(axis=X, base_centre=(-59.6mm, 22.5mm, 0mm), radius=0.25mm, height=6.85mm, segments=12)
  Dipole_073_R [pec] = cylinder(axis=X, base_centre=(-52.25mm, 22.5mm, 0mm), radius=0.25mm, height=6.85mm, segments=12)
  PortSheet_073 = rectangle(corner=(-52.75mm, 22.5mm, -0.5mm), z_size=0.5mm, x_size=1mm)
  Dipole_074_L [pec] = cylinder(axis=X, base_centre=(-59.6mm, 37.5mm, 0mm), radius=0.25mm, height=6.85mm, segments=12)
  Dipole_074_R [pec] = cylinder(axis=X, base_centre=(-52.25mm, 37.5mm, 0mm), radius=0.25mm, height=6.85mm, segments=12)
  PortSheet_074 = rectangle(corner=(-52.75mm, 37.5mm, -0.5mm), z_size=0.5mm, x_size=1mm)
  Dipole_075_L [pec] = cylinder(axis=X, base_centre=(-59.6mm, 52.5mm, 0mm), radius=0.25mm, height=6.85mm, segments=12)
  Dipole_075_R [pec] = cylinder(axis=X, base_centre=(-52.25mm, 52.5mm, 0mm), radius=0.25mm, height=6.85mm, segments=12)
  PortSheet_075 = rectangle(corner=(-52.75mm, 52.5mm, -0.5mm), z_size=0.5mm, x_size=1mm)
  Dipole_076_L [pec] = cylinder(axis=X, base_centre=(-59.6mm, 67.5mm, 0mm), radius=0.25mm, height=6.85mm, segments=12)
  Dipole_076_R [pec] = cylinder(axis=X, base_centre=(-52.25mm, 67.5mm, 0mm), radius=0.25mm, height=6.85mm, segments=12)
  PortSheet_076 = rectangle(corner=(-52.75mm, 67.5mm, -0.5mm), z_size=0.5mm, x_size=1mm)
  Dipole_077_L [pec] = cylinder(axis=X, base_centre=(-59.6mm, 82.5mm, 0mm), radius=0.25mm, height=6.85mm, segments=12)
  Dipole_077_R [pec] = cylinder(axis=X, base_centre=(-52.25mm, 82.5mm, 0mm), radius=0.25mm, height=6.85mm, segments=12)
  PortSheet_077 = rectangle(corner=(-52.75mm, 82.5mm, -0.5mm), z_size=0.5mm, x_size=1mm)
  Dipole_078_L [pec] = cylinder(axis=X, base_centre=(-59.6mm, 97.5mm, 0mm), radius=0.25mm, height=6.85mm, segments=12)
  Dipole_078_R [pec] = cylinder(axis=X, base_centre=(-52.25mm, 97.5mm, 0mm), radius=0.25mm, height=6.85mm, segments=12)
  PortSheet_078 = rectangle(corner=(-52.75mm, 97.5mm, -0.5mm), z_size=0.5mm, x_size=1mm)
  Dipole_079_L [pec] = cylinder(axis=X, base_centre=(-59.6mm, 112.5mm, 0mm), radius=0.25mm, height=6.85mm, segments=12)
  Dipole_079_R [pec] = cylinder(axis=X, base_centre=(-52.25mm, 112.5mm, 0mm), radius=0.25mm, height=6.85mm, segments=12)
  PortSheet_079 = rectangle(corner=(-52.75mm, 112.5mm, -0.5mm), z_size=0.5mm, x_size=1mm)
  Dipole_080_L [pec] = cylinder(axis=X, base_centre=(-44.6mm, -112.5mm, 0mm), radius=0.25mm, height=6.85mm, segments=12)
  Dipole_080_R [pec] = cylinder(axis=X, base_centre=(-37.25mm, -112.5mm, 0mm), radius=0.25mm, height=6.85mm, segments=12)
  PortSheet_080 = rectangle(corner=(-37.75mm, -112.5mm, -0.5mm), z_size=0.5mm, x_size=1mm)
  Dipole_081_L [pec] = cylinder(axis=X, base_centre=(-44.6mm, -97.5mm, 0mm), radius=0.25mm, height=6.85mm, segments=12)
  Dipole_081_R [pec] = cylinder(axis=X, base_centre=(-37.25mm, -97.5mm, 0mm), radius=0.25mm, height=6.85mm, segments=12)
  PortSheet_081 = rectangle(corner=(-37.75mm, -97.5mm, -0.5mm), z_size=0.5mm, x_size=1mm)
  Dipole_082_L [pec] = cylinder(axis=X, base_centre=(-44.6mm, -82.5mm, 0mm), radius=0.25mm, height=6.85mm, segments=12)
  Dipole_082_R [pec] = cylinder(axis=X, base_centre=(-37.25mm, -82.5mm, 0mm), radius=0.25mm, height=6.85mm, segments=12)
  PortSheet_082 = rectangle(corner=(-37.75mm, -82.5mm, -0.5mm), z_size=0.5mm, x_size=1mm)
  Dipole_083_L [pec] = cylinder(axis=X, base_centre=(-44.6mm, -67.5mm, 0mm), radius=0.25mm, height=6.85mm, segments=12)
  Dipole_083_R [pec] = cylinder(axis=X, base_centre=(-37.25mm, -67.5mm, 0mm), radius=0.25mm, height=6.85mm, segments=12)
  PortSheet_083 = rectangle(corner=(-37.75mm, -67.5mm, -0.5mm), z_size=0.5mm, x_size=1mm)
  Dipole_084_L [pec] = cylinder(axis=X, base_centre=(-44.6mm, -52.5mm, 0mm), radius=0.25mm, height=6.85mm, segments=12)
  Dipole_084_R [pec] = cylinder(axis=X, base_centre=(-37.25mm, -52.5mm, 0mm), radius=0.25mm, height=6.85mm, segments=12)
  PortSheet_084 = rectangle(corner=(-37.75mm, -52.5mm, -0.5mm), z_size=0.5mm, x_size=1mm)
  Dipole_085_L [pec] = cylinder(axis=X, base_centre=(-44.6mm, -37.5mm, 0mm), radius=0.25mm, height=6.85mm, segments=12)
  Dipole_085_R [pec] = cylinder(axis=X, base_centre=(-37.25mm, -37.5mm, 0mm), radius=0.25mm, height=6.85mm, segments=12)
  PortSheet_085 = rectangle(corner=(-37.75mm, -37.5mm, -0.5mm), z_size=0.5mm, x_size=1mm)
  Dipole_086_L [pec] = cylinder(axis=X, base_centre=(-44.6mm, -22.5mm, 0mm), radius=0.25mm, height=6.85mm, segments=12)
  Dipole_086_R [pec] = cylinder(axis=X, base_centre=(-37.25mm, -22.5mm, 0mm), radius=0.25mm, height=6.85mm, segments=12)
  PortSheet_086 = rectangle(corner=(-37.75mm, -22.5mm, -0.5mm), z_size=0.5mm, x_size=1mm)
  Dipole_087_L [pec] = cylinder(axis=X, base_centre=(-44.6mm, -7.5mm, 0mm), radius=0.25mm, height=6.85mm, segments=12)
  Dipole_087_R [pec] = cylinder(axis=X, base_centre=(-37.25mm, -7.5mm, 0mm), radius=0.25mm, height=6.85mm, segments=12)
  PortSheet_087 = rectangle(corner=(-37.75mm, -7.5mm, -0.5mm), z_size=0.5mm, x_size=1mm)
  Dipole_088_L [pec] = cylinder(axis=X, base_centre=(-44.6mm, 7.5mm, 0mm), radius=0.25mm, height=6.85mm, segments=12)
  Dipole_088_R [pec] = cylinder(axis=X, base_centre=(-37.25mm, 7.5mm, 0mm), radius=0.25mm, height=6.85mm, segments=12)
  PortSheet_088 = rectangle(corner=(-37.75mm, 7.5mm, -0.5mm), z_size=0.5mm, x_size=1mm)
  Dipole_089_L [pec] = cylinder(axis=X, base_centre=(-44.6mm, 22.5mm, 0mm), radius=0.25mm, height=6.85mm, segments=12)
  Dipole_089_R [pec] = cylinder(axis=X, base_centre=(-37.25mm, 22.5mm, 0mm), radius=0.25mm, height=6.85mm, segments=12)
  PortSheet_089 = rectangle(corner=(-37.75mm, 22.5mm, -0.5mm), z_size=0.5mm, x_size=1mm)
  Dipole_090_L [pec] = cylinder(axis=X, base_centre=(-44.6mm, 37.5mm, 0mm), radius=0.25mm, height=6.85mm, segments=12)
  Dipole_090_R [pec] = cylinder(axis=X, base_centre=(-37.25mm, 37.5mm, 0mm), radius=0.25mm, height=6.85mm, segments=12)
  PortSheet_090 = rectangle(corner=(-37.75mm, 37.5mm, -0.5mm), z_size=0.5mm, x_size=1mm)
  Dipole_091_L [pec] = cylinder(axis=X, base_centre=(-44.6mm, 52.5mm, 0mm), radius=0.25mm, height=6.85mm, segments=12)
  Dipole_091_R [pec] = cylinder(axis=X, base_centre=(-37.25mm, 52.5mm, 0mm), radius=0.25mm, height=6.85mm, segments=12)
  PortSheet_091 = rectangle(corner=(-37.75mm, 52.5mm, -0.5mm), z_size=0.5mm, x_size=1mm)
  Dipole_092_L [pec] = cylinder(axis=X, base_centre=(-44.6mm, 67.5mm, 0mm), radius=0.25mm, height=6.85mm, segments=12)
  Dipole_092_R [pec] = cylinder(axis=X, base_centre=(-37.25mm, 67.5mm, 0mm), radius=0.25mm, height=6.85mm, segments=12)
  PortSheet_092 = rectangle(corner=(-37.75mm, 67.5mm, -0.5mm), z_size=0.5mm, x_size=1mm)
  Dipole_093_L [pec] = cylinder(axis=X, base_centre=(-44.6mm, 82.5mm, 0mm), radius=0.25mm, height=6.85mm, segments=12)
  Dipole_093_R [pec] = cylinder(axis=X, base_centre=(-37.25mm, 82.5mm, 0mm), radius=0.25mm, height=6.85mm, segments=12)
  PortSheet_093 = rectangle(corner=(-37.75mm, 82.5mm, -0.5mm), z_size=0.5mm, x_size=1mm)
  Dipole_094_L [pec] = cylinder(axis=X, base_centre=(-44.6mm, 97.5mm, 0mm), radius=0.25mm, height=6.85mm, segments=12)
  Dipole_094_R [pec] = cylinder(axis=X, base_centre=(-37.25mm, 97.5mm, 0mm), radius=0.25mm, height=6.85mm, segments=12)
  PortSheet_094 = rectangle(corner=(-37.75mm, 97.5mm, -0.5mm), z_size=0.5mm, x_size=1mm)
  Dipole_095_L [pec] = cylinder(axis=X, base_centre=(-44.6mm, 112.5mm, 0mm), radius=0.25mm, height=6.85mm, segments=12)
  Dipole_095_R [pec] = cylinder(axis=X, base_centre=(-37.25mm, 112.5mm, 0mm), radius=0.25mm, height=6.85mm, segments=12)
  PortSheet_095 = rectangle(corner=(-37.75mm, 112.5mm, -0.5mm), z_size=0.5mm, x_size=1mm)
  Dipole_096_L [pec] = cylinder(axis=X, base_centre=(-29.6mm, -112.5mm, 0mm), radius=0.25mm, height=6.85mm, segments=12)
  Dipole_096_R [pec] = cylinder(axis=X, base_centre=(-22.25mm, -112.5mm, 0mm), radius=0.25mm, height=6.85mm, segments=12)
  PortSheet_096 = rectangle(corner=(-22.75mm, -112.5mm, -0.5mm), z_size=0.5mm, x_size=1mm)
  Dipole_097_L [pec] = cylinder(axis=X, base_centre=(-29.6mm, -97.5mm, 0mm), radius=0.25mm, height=6.85mm, segments=12)
  Dipole_097_R [pec] = cylinder(axis=X, base_centre=(-22.25mm, -97.5mm, 0mm), radius=0.25mm, height=6.85mm, segments=12)
  PortSheet_097 = rectangle(corner=(-22.75mm, -97.5mm, -0.5mm), z_size=0.5mm, x_size=1mm)
  Dipole_098_L [pec] = cylinder(axis=X, base_centre=(-29.6mm, -82.5mm, 0mm), radius=0.25mm, height=6.85mm, segments=12)
  Dipole_098_R [pec] = cylinder(axis=X, base_centre=(-22.25mm, -82.5mm, 0mm), radius=0.25mm, height=6.85mm, segments=12)
  PortSheet_098 = rectangle(corner=(-22.75mm, -82.5mm, -0.5mm), z_size=0.5mm, x_size=1mm)
  Dipole_099_L [pec] = cylinder(axis=X, base_centre=(-29.6mm, -67.5mm, 0mm), radius=0.25mm, height=6.85mm, segments=12)
  Dipole_099_R [pec] = cylinder(axis=X, base_centre=(-22.25mm, -67.5mm, 0mm), radius=0.25mm, height=6.85mm, segments=12)
  PortSheet_099 = rectangle(corner=(-22.75mm, -67.5mm, -0.5mm), z_size=0.5mm, x_size=1mm)
  Dipole_100_L [pec] = cylinder(axis=X, base_centre=(-29.6mm, -52.5mm, 0mm), radius=0.25mm, height=6.85mm, segments=12)
  Dipole_100_R [pec] = cylinder(axis=X, base_centre=(-22.25mm, -52.5mm, 0mm), radius=0.25mm, height=6.85mm, segments=12)
  PortSheet_100 = rectangle(corner=(-22.75mm, -52.5mm, -0.5mm), z_size=0.5mm, x_size=1mm)
  Dipole_101_L [pec] = cylinder(axis=X, base_centre=(-29.6mm, -37.5mm, 0mm), radius=0.25mm, height=6.85mm, segments=12)
  Dipole_101_R [pec] = cylinder(axis=X, base_centre=(-22.25mm, -37.5mm, 0mm), radius=0.25mm, height=6.85mm, segments=12)
  PortSheet_101 = rectangle(corner=(-22.75mm, -37.5mm, -0.5mm), z_size=0.5mm, x_size=1mm)
  Dipole_102_L [pec] = cylinder(axis=X, base_centre=(-29.6mm, -22.5mm, 0mm), radius=0.25mm, height=6.85mm, segments=12)
  Dipole_102_R [pec] = cylinder(axis=X, base_centre=(-22.25mm, -22.5mm, 0mm), radius=0.25mm, height=6.85mm, segments=12)
  PortSheet_102 = rectangle(corner=(-22.75mm, -22.5mm, -0.5mm), z_size=0.5mm, x_size=1mm)
  Dipole_103_L [pec] = cylinder(axis=X, base_centre=(-29.6mm, -7.5mm, 0mm), radius=0.25mm, height=6.85mm, segments=12)
  Dipole_103_R [pec] = cylinder(axis=X, base_centre=(-22.25mm, -7.5mm, 0mm), radius=0.25mm, height=6.85mm, segments=12)
  PortSheet_103 = rectangle(corner=(-22.75mm, -7.5mm, -0.5mm), z_size=0.5mm, x_size=1mm)
  Dipole_104_L [pec] = cylinder(axis=X, base_centre=(-29.6mm, 7.5mm, 0mm), radius=0.25mm, height=6.85mm, segments=12)
  Dipole_104_R [pec] = cylinder(axis=X, base_centre=(-22.25mm, 7.5mm, 0mm), radius=0.25mm, height=6.85mm, segments=12)
  PortSheet_104 = rectangle(corner=(-22.75mm, 7.5mm, -0.5mm), z_size=0.5mm, x_size=1mm)
  Dipole_105_L [pec] = cylinder(axis=X, base_centre=(-29.6mm, 22.5mm, 0mm), radius=0.25mm, height=6.85mm, segments=12)
  Dipole_105_R [pec] = cylinder(axis=X, base_centre=(-22.25mm, 22.5mm, 0mm), radius=0.25mm, height=6.85mm, segments=12)
  PortSheet_105 = rectangle(corner=(-22.75mm, 22.5mm, -0.5mm), z_size=0.5mm, x_size=1mm)
  Dipole_106_L [pec] = cylinder(axis=X, base_centre=(-29.6mm, 37.5mm, 0mm), radius=0.25mm, height=6.85mm, segments=12)
  Dipole_106_R [pec] = cylinder(axis=X, base_centre=(-22.25mm, 37.5mm, 0mm), radius=0.25mm, height=6.85mm, segments=12)
  PortSheet_106 = rectangle(corner=(-22.75mm, 37.5mm, -0.5mm), z_size=0.5mm, x_size=1mm)
  Dipole_107_L [pec] = cylinder(axis=X, base_centre=(-29.6mm, 52.5mm, 0mm), radius=0.25mm, height=6.85mm, segments=12)
  Dipole_107_R [pec] = cylinder(axis=X, base_centre=(-22.25mm, 52.5mm, 0mm), radius=0.25mm, height=6.85mm, segments=12)
  PortSheet_107 = rectangle(corner=(-22.75mm, 52.5mm, -0.5mm), z_size=0.5mm, x_size=1mm)
  Dipole_108_L [pec] = cylinder(axis=X, base_centre=(-29.6mm, 67.5mm, 0mm), radius=0.25mm, height=6.85mm, segments=12)
  Dipole_108_R [pec] = cylinder(axis=X, base_centre=(-22.25mm, 67.5mm, 0mm), radius=0.25mm, height=6.85mm, segments=12)
  PortSheet_108 = rectangle(corner=(-22.75mm, 67.5mm, -0.5mm), z_size=0.5mm, x_size=1mm)
  Dipole_109_L [pec] = cylinder(axis=X, base_centre=(-29.6mm, 82.5mm, 0mm), radius=0.25mm, height=6.85mm, segments=12)
  Dipole_109_R [pec] = cylinder(axis=X, base_centre=(-22.25mm, 82.5mm, 0mm), radius=0.25mm, height=6.85mm, segments=12)
  PortSheet_109 = rectangle(corner=(-22.75mm, 82.5mm, -0.5mm), z_size=0.5mm, x_size=1mm)
  Dipole_110_L [pec] = cylinder(axis=X, base_centre=(-29.6mm, 97.5mm, 0mm), radius=0.25mm, height=6.85mm, segments=12)
  Dipole_110_R [pec] = cylinder(axis=X, base_centre=(-22.25mm, 97.5mm, 0mm), radius=0.25mm, height=6.85mm, segments=12)
  PortSheet_110 = rectangle(corner=(-22.75mm, 97.5mm, -0.5mm), z_size=0.5mm, x_size=1mm)
  Dipole_111_L [pec] = cylinder(axis=X, base_centre=(-29.6mm, 112.5mm, 0mm), radius=0.25mm, height=6.85mm, segments=12)
  Dipole_111_R [pec] = cylinder(axis=X, base_centre=(-22.25mm, 112.5mm, 0mm), radius=0.25mm, height=6.85mm, segments=12)
  PortSheet_111 = rectangle(corner=(-22.75mm, 112.5mm, -0.5mm), z_size=0.5mm, x_size=1mm)
  Dipole_112_L [pec] = cylinder(axis=X, base_centre=(-14.6mm, -112.5mm, 0mm), radius=0.25mm, height=6.85mm, segments=12)
  Dipole_112_R [pec] = cylinder(axis=X, base_centre=(-7.25mm, -112.5mm, 0mm), radius=0.25mm, height=6.85mm, segments=12)
  PortSheet_112 = rectangle(corner=(-7.75mm, -112.5mm, -0.5mm), z_size=0.5mm, x_size=1mm)
  Dipole_113_L [pec] = cylinder(axis=X, base_centre=(-14.6mm, -97.5mm, 0mm), radius=0.25mm, height=6.85mm, segments=12)
  Dipole_113_R [pec] = cylinder(axis=X, base_centre=(-7.25mm, -97.5mm, 0mm), radius=0.25mm, height=6.85mm, segments=12)
  PortSheet_113 = rectangle(corner=(-7.75mm, -97.5mm, -0.5mm), z_size=0.5mm, x_size=1mm)
  Dipole_114_L [pec] = cylinder(axis=X, base_centre=(-14.6mm, -82.5mm, 0mm), radius=0.25mm, height=6.85mm, segments=12)
  Dipole_114_R [pec] = cylinder(axis=X, base_centre=(-7.25mm, -82.5mm, 0mm), radius=0.25mm, height=6.85mm, segments=12)
  PortSheet_114 = rectangle(corner=(-7.75mm, -82.5mm, -0.5mm), z_size=0.5mm, x_size=1mm)
  Dipole_115_L [pec] = cylinder(axis=X, base_centre=(-14.6mm, -67.5mm, 0mm), radius=0.25mm, height=6.85mm, segments=12)
  Dipole_115_R [pec] = cylinder(axis=X, base_centre=(-7.25mm, -67.5mm, 0mm), radius=0.25mm, height=6.85mm, segments=12)
  PortSheet_115 = rectangle(corner=(-7.75mm, -67.5mm, -0.5mm), z_size=0.5mm, x_size=1mm)
  Dipole_116_L [pec] = cylinder(axis=X, base_centre=(-14.6mm, -52.5mm, 0mm), radius=0.25mm, height=6.85mm, segments=12)
  Dipole_116_R [pec] = cylinder(axis=X, base_centre=(-7.25mm, -52.5mm, 0mm), radius=0.25mm, height=6.85mm, segments=12)
  PortSheet_116 = rectangle(corner=(-7.75mm, -52.5mm, -0.5mm), z_size=0.5mm, x_size=1mm)
  Dipole_117_L [pec] = cylinder(axis=X, base_centre=(-14.6mm, -37.5mm, 0mm), radius=0.25mm, height=6.85mm, segments=12)
  Dipole_117_R [pec] = cylinder(axis=X, base_centre=(-7.25mm, -37.5mm, 0mm), radius=0.25mm, height=6.85mm, segments=12)
  PortSheet_117 = rectangle(corner=(-7.75mm, -37.5mm, -0.5mm), z_size=0.5mm, x_size=1mm)
  Dipole_118_L [pec] = cylinder(axis=X, base_centre=(-14.6mm, -22.5mm, 0mm), radius=0.25mm, height=6.85mm, segments=12)
  Dipole_118_R [pec] = cylinder(axis=X, base_centre=(-7.25mm, -22.5mm, 0mm), radius=0.25mm, height=6.85mm, segments=12)
  PortSheet_118 = rectangle(corner=(-7.75mm, -22.5mm, -0.5mm), z_size=0.5mm, x_size=1mm)
  Dipole_119_L [pec] = cylinder(axis=X, base_centre=(-14.6mm, -7.5mm, 0mm), radius=0.25mm, height=6.85mm, segments=12)
  Dipole_119_R [pec] = cylinder(axis=X, base_centre=(-7.25mm, -7.5mm, 0mm), radius=0.25mm, height=6.85mm, segments=12)
  PortSheet_119 = rectangle(corner=(-7.75mm, -7.5mm, -0.5mm), z_size=0.5mm, x_size=1mm)
  Dipole_120_L [pec] = cylinder(axis=X, base_centre=(-14.6mm, 7.5mm, 0mm), radius=0.25mm, height=6.85mm, segments=12)
  Dipole_120_R [pec] = cylinder(axis=X, base_centre=(-7.25mm, 7.5mm, 0mm), radius=0.25mm, height=6.85mm, segments=12)
  PortSheet_120 = rectangle(corner=(-7.75mm, 7.5mm, -0.5mm), z_size=0.5mm, x_size=1mm)
  Dipole_121_L [pec] = cylinder(axis=X, base_centre=(-14.6mm, 22.5mm, 0mm), radius=0.25mm, height=6.85mm, segments=12)
  Dipole_121_R [pec] = cylinder(axis=X, base_centre=(-7.25mm, 22.5mm, 0mm), radius=0.25mm, height=6.85mm, segments=12)
  PortSheet_121 = rectangle(corner=(-7.75mm, 22.5mm, -0.5mm), z_size=0.5mm, x_size=1mm)
  Dipole_122_L [pec] = cylinder(axis=X, base_centre=(-14.6mm, 37.5mm, 0mm), radius=0.25mm, height=6.85mm, segments=12)
  Dipole_122_R [pec] = cylinder(axis=X, base_centre=(-7.25mm, 37.5mm, 0mm), radius=0.25mm, height=6.85mm, segments=12)
  PortSheet_122 = rectangle(corner=(-7.75mm, 37.5mm, -0.5mm), z_size=0.5mm, x_size=1mm)
  Dipole_123_L [pec] = cylinder(axis=X, base_centre=(-14.6mm, 52.5mm, 0mm), radius=0.25mm, height=6.85mm, segments=12)
  Dipole_123_R [pec] = cylinder(axis=X, base_centre=(-7.25mm, 52.5mm, 0mm), radius=0.25mm, height=6.85mm, segments=12)
  PortSheet_123 = rectangle(corner=(-7.75mm, 52.5mm, -0.5mm), z_size=0.5mm, x_size=1mm)
  Dipole_124_L [pec] = cylinder(axis=X, base_centre=(-14.6mm, 67.5mm, 0mm), radius=0.25mm, height=6.85mm, segments=12)
  Dipole_124_R [pec] = cylinder(axis=X, base_centre=(-7.25mm, 67.5mm, 0mm), radius=0.25mm, height=6.85mm, segments=12)
  PortSheet_124 = rectangle(corner=(-7.75mm, 67.5mm, -0.5mm), z_size=0.5mm, x_size=1mm)
  Dipole_125_L [pec] = cylinder(axis=X, base_centre=(-14.6mm, 82.5mm, 0mm), radius=0.25mm, height=6.85mm, segments=12)
  Dipole_125_R [pec] = cylinder(axis=X, base_centre=(-7.25mm, 82.5mm, 0mm), radius=0.25mm, height=6.85mm, segments=12)
  PortSheet_125 = rectangle(corner=(-7.75mm, 82.5mm, -0.5mm), z_size=0.5mm, x_size=1mm)
  Dipole_126_L [pec] = cylinder(axis=X, base_centre=(-14.6mm, 97.5mm, 0mm), radius=0.25mm, height=6.85mm, segments=12)
  Dipole_126_R [pec] = cylinder(axis=X, base_centre=(-7.25mm, 97.5mm, 0mm), radius=0.25mm, height=6.85mm, segments=12)
  PortSheet_126 = rectangle(corner=(-7.75mm, 97.5mm, -0.5mm), z_size=0.5mm, x_size=1mm)
  Dipole_127_L [pec] = cylinder(axis=X, base_centre=(-14.6mm, 112.5mm, 0mm), radius=0.25mm, height=6.85mm, segments=12)
  Dipole_127_R [pec] = cylinder(axis=X, base_centre=(-7.25mm, 112.5mm, 0mm), radius=0.25mm, height=6.85mm, segments=12)
  PortSheet_127 = rectangle(corner=(-7.75mm, 112.5mm, -0.5mm), z_size=0.5mm, x_size=1mm)
  Dipole_128_L [pec] = cylinder(axis=X, base_centre=(0.4mm, -112.5mm, 0mm), radius=0.25mm, height=6.85mm, segments=12)
  Dipole_128_R [pec] = cylinder(axis=X, base_centre=(7.75mm, -112.5mm, 0mm), radius=0.25mm, height=6.85mm, segments=12)
  PortSheet_128 = rectangle(corner=(7.25mm, -112.5mm, -0.5mm), z_size=0.5mm, x_size=1mm)
  Dipole_129_L [pec] = cylinder(axis=X, base_centre=(0.4mm, -97.5mm, 0mm), radius=0.25mm, height=6.85mm, segments=12)
  Dipole_129_R [pec] = cylinder(axis=X, base_centre=(7.75mm, -97.5mm, 0mm), radius=0.25mm, height=6.85mm, segments=12)
  PortSheet_129 = rectangle(corner=(7.25mm, -97.5mm, -0.5mm), z_size=0.5mm, x_size=1mm)
  Dipole_130_L [pec] = cylinder(axis=X, base_centre=(0.4mm, -82.5mm, 0mm), radius=0.25mm, height=6.85mm, segments=12)
  Dipole_130_R [pec] = cylinder(axis=X, base_centre=(7.75mm, -82.5mm, 0mm), radius=0.25mm, height=6.85mm, segments=12)
  PortSheet_130 = rectangle(corner=(7.25mm, -82.5mm, -0.5mm), z_size=0.5mm, x_size=1mm)
  Dipole_131_L [pec] = cylinder(axis=X, base_centre=(0.4mm, -67.5mm, 0mm), radius=0.25mm, height=6.85mm, segments=12)
  Dipole_131_R [pec] = cylinder(axis=X, base_centre=(7.75mm, -67.5mm, 0mm), radius=0.25mm, height=6.85mm, segments=12)
  PortSheet_131 = rectangle(corner=(7.25mm, -67.5mm, -0.5mm), z_size=0.5mm, x_size=1mm)
  Dipole_132_L [pec] = cylinder(axis=X, base_centre=(0.4mm, -52.5mm, 0mm), radius=0.25mm, height=6.85mm, segments=12)
  Dipole_132_R [pec] = cylinder(axis=X, base_centre=(7.75mm, -52.5mm, 0mm), radius=0.25mm, height=6.85mm, segments=12)
  PortSheet_132 = rectangle(corner=(7.25mm, -52.5mm, -0.5mm), z_size=0.5mm, x_size=1mm)
  Dipole_133_L [pec] = cylinder(axis=X, base_centre=(0.4mm, -37.5mm, 0mm), radius=0.25mm, height=6.85mm, segments=12)
  Dipole_133_R [pec] = cylinder(axis=X, base_centre=(7.75mm, -37.5mm, 0mm), radius=0.25mm, height=6.85mm, segments=12)
  PortSheet_133 = rectangle(corner=(7.25mm, -37.5mm, -0.5mm), z_size=0.5mm, x_size=1mm)
  Dipole_134_L [pec] = cylinder(axis=X, base_centre=(0.4mm, -22.5mm, 0mm), radius=0.25mm, height=6.85mm, segments=12)
  Dipole_134_R [pec] = cylinder(axis=X, base_centre=(7.75mm, -22.5mm, 0mm), radius=0.25mm, height=6.85mm, segments=12)
  PortSheet_134 = rectangle(corner=(7.25mm, -22.5mm, -0.5mm), z_size=0.5mm, x_size=1mm)
  Dipole_135_L [pec] = cylinder(axis=X, base_centre=(0.4mm, -7.5mm, 0mm), radius=0.25mm, height=6.85mm, segments=12)
  Dipole_135_R [pec] = cylinder(axis=X, base_centre=(7.75mm, -7.5mm, 0mm), radius=0.25mm, height=6.85mm, segments=12)
  PortSheet_135 = rectangle(corner=(7.25mm, -7.5mm, -0.5mm), z_size=0.5mm, x_size=1mm)
  Dipole_136_L [pec] = cylinder(axis=X, base_centre=(0.4mm, 7.5mm, 0mm), radius=0.25mm, height=6.85mm, segments=12)
  Dipole_136_R [pec] = cylinder(axis=X, base_centre=(7.75mm, 7.5mm, 0mm), radius=0.25mm, height=6.85mm, segments=12)
  PortSheet_136 = rectangle(corner=(7.25mm, 7.5mm, -0.5mm), z_size=0.5mm, x_size=1mm)
  Dipole_137_L [pec] = cylinder(axis=X, base_centre=(0.4mm, 22.5mm, 0mm), radius=0.25mm, height=6.85mm, segments=12)
  Dipole_137_R [pec] = cylinder(axis=X, base_centre=(7.75mm, 22.5mm, 0mm), radius=0.25mm, height=6.85mm, segments=12)
  PortSheet_137 = rectangle(corner=(7.25mm, 22.5mm, -0.5mm), z_size=0.5mm, x_size=1mm)
  Dipole_138_L [pec] = cylinder(axis=X, base_centre=(0.4mm, 37.5mm, 0mm), radius=0.25mm, height=6.85mm, segments=12)
  Dipole_138_R [pec] = cylinder(axis=X, base_centre=(7.75mm, 37.5mm, 0mm), radius=0.25mm, height=6.85mm, segments=12)
  PortSheet_138 = rectangle(corner=(7.25mm, 37.5mm, -0.5mm), z_size=0.5mm, x_size=1mm)
  Dipole_139_L [pec] = cylinder(axis=X, base_centre=(0.4mm, 52.5mm, 0mm), radius=0.25mm, height=6.85mm, segments=12)
  Dipole_139_R [pec] = cylinder(axis=X, base_centre=(7.75mm, 52.5mm, 0mm), radius=0.25mm, height=6.85mm, segments=12)
  PortSheet_139 = rectangle(corner=(7.25mm, 52.5mm, -0.5mm), z_size=0.5mm, x_size=1mm)
  Dipole_140_L [pec] = cylinder(axis=X, base_centre=(0.4mm, 67.5mm, 0mm), radius=0.25mm, height=6.85mm, segments=12)
  Dipole_140_R [pec] = cylinder(axis=X, base_centre=(7.75mm, 67.5mm, 0mm), radius=0.25mm, height=6.85mm, segments=12)
  PortSheet_140 = rectangle(corner=(7.25mm, 67.5mm, -0.5mm), z_size=0.5mm, x_size=1mm)
  Dipole_141_L [pec] = cylinder(axis=X, base_centre=(0.4mm, 82.5mm, 0mm), radius=0.25mm, height=6.85mm, segments=12)
  Dipole_141_R [pec] = cylinder(axis=X, base_centre=(7.75mm, 82.5mm, 0mm), radius=0.25mm, height=6.85mm, segments=12)
  PortSheet_141 = rectangle(corner=(7.25mm, 82.5mm, -0.5mm), z_size=0.5mm, x_size=1mm)
  Dipole_142_L [pec] = cylinder(axis=X, base_centre=(0.4mm, 97.5mm, 0mm), radius=0.25mm, height=6.85mm, segments=12)
  Dipole_142_R [pec] = cylinder(axis=X, base_centre=(7.75mm, 97.5mm, 0mm), radius=0.25mm, height=6.85mm, segments=12)
  PortSheet_142 = rectangle(corner=(7.25mm, 97.5mm, -0.5mm), z_size=0.5mm, x_size=1mm)
  Dipole_143_L [pec] = cylinder(axis=X, base_centre=(0.4mm, 112.5mm, 0mm), radius=0.25mm, height=6.85mm, segments=12)
  Dipole_143_R [pec] = cylinder(axis=X, base_centre=(7.75mm, 112.5mm, 0mm), radius=0.25mm, height=6.85mm, segments=12)
  PortSheet_143 = rectangle(corner=(7.25mm, 112.5mm, -0.5mm), z_size=0.5mm, x_size=1mm)
  Dipole_144_L [pec] = cylinder(axis=X, base_centre=(15.4mm, -112.5mm, 0mm), radius=0.25mm, height=6.85mm, segments=12)
  Dipole_144_R [pec] = cylinder(axis=X, base_centre=(22.75mm, -112.5mm, 0mm), radius=0.25mm, height=6.85mm, segments=12)
  PortSheet_144 = rectangle(corner=(22.25mm, -112.5mm, -0.5mm), z_size=0.5mm, x_size=1mm)
  Dipole_145_L [pec] = cylinder(axis=X, base_centre=(15.4mm, -97.5mm, 0mm), radius=0.25mm, height=6.85mm, segments=12)
  Dipole_145_R [pec] = cylinder(axis=X, base_centre=(22.75mm, -97.5mm, 0mm), radius=0.25mm, height=6.85mm, segments=12)
  PortSheet_145 = rectangle(corner=(22.25mm, -97.5mm, -0.5mm), z_size=0.5mm, x_size=1mm)
  Dipole_146_L [pec] = cylinder(axis=X, base_centre=(15.4mm, -82.5mm, 0mm), radius=0.25mm, height=6.85mm, segments=12)
  Dipole_146_R [pec] = cylinder(axis=X, base_centre=(22.75mm, -82.5mm, 0mm), radius=0.25mm, height=6.85mm, segments=12)
  PortSheet_146 = rectangle(corner=(22.25mm, -82.5mm, -0.5mm), z_size=0.5mm, x_size=1mm)
  Dipole_147_L [pec] = cylinder(axis=X, base_centre=(15.4mm, -67.5mm, 0mm), radius=0.25mm, height=6.85mm, segments=12)
  Dipole_147_R [pec] = cylinder(axis=X, base_centre=(22.75mm, -67.5mm, 0mm), radius=0.25mm, height=6.85mm, segments=12)
  PortSheet_147 = rectangle(corner=(22.25mm, -67.5mm, -0.5mm), z_size=0.5mm, x_size=1mm)
  Dipole_148_L [pec] = cylinder(axis=X, base_centre=(15.4mm, -52.5mm, 0mm), radius=0.25mm, height=6.85mm, segments=12)
  Dipole_148_R [pec] = cylinder(axis=X, base_centre=(22.75mm, -52.5mm, 0mm), radius=0.25mm, height=6.85mm, segments=12)
  PortSheet_148 = rectangle(corner=(22.25mm, -52.5mm, -0.5mm), z_size=0.5mm, x_size=1mm)
  Dipole_149_L [pec] = cylinder(axis=X, base_centre=(15.4mm, -37.5mm, 0mm), radius=0.25mm, height=6.85mm, segments=12)
  Dipole_149_R [pec] = cylinder(axis=X, base_centre=(22.75mm, -37.5mm, 0mm), radius=0.25mm, height=6.85mm, segments=12)
  PortSheet_149 = rectangle(corner=(22.25mm, -37.5mm, -0.5mm), z_size=0.5mm, x_size=1mm)
  Dipole_150_L [pec] = cylinder(axis=X, base_centre=(15.4mm, -22.5mm, 0mm), radius=0.25mm, height=6.85mm, segments=12)
  Dipole_150_R [pec] = cylinder(axis=X, base_centre=(22.75mm, -22.5mm, 0mm), radius=0.25mm, height=6.85mm, segments=12)
  PortSheet_150 = rectangle(corner=(22.25mm, -22.5mm, -0.5mm), z_size=0.5mm, x_size=1mm)
  Dipole_151_L [pec] = cylinder(axis=X, base_centre=(15.4mm, -7.5mm, 0mm), radius=0.25mm, height=6.85mm, segments=12)
  Dipole_151_R [pec] = cylinder(axis=X, base_centre=(22.75mm, -7.5mm, 0mm), radius=0.25mm, height=6.85mm, segments=12)
  PortSheet_151 = rectangle(corner=(22.25mm, -7.5mm, -0.5mm), z_size=0.5mm, x_size=1mm)
  Dipole_152_L [pec] = cylinder(axis=X, base_centre=(15.4mm, 7.5mm, 0mm), radius=0.25mm, height=6.85mm, segments=12)
  Dipole_152_R [pec] = cylinder(axis=X, base_centre=(22.75mm, 7.5mm, 0mm), radius=0.25mm, height=6.85mm, segments=12)
  PortSheet_152 = rectangle(corner=(22.25mm, 7.5mm, -0.5mm), z_size=0.5mm, x_size=1mm)
  Dipole_153_L [pec] = cylinder(axis=X, base_centre=(15.4mm, 22.5mm, 0mm), radius=0.25mm, height=6.85mm, segments=12)
  Dipole_153_R [pec] = cylinder(axis=X, base_centre=(22.75mm, 22.5mm, 0mm), radius=0.25mm, height=6.85mm, segments=12)
  PortSheet_153 = rectangle(corner=(22.25mm, 22.5mm, -0.5mm), z_size=0.5mm, x_size=1mm)
  Dipole_154_L [pec] = cylinder(axis=X, base_centre=(15.4mm, 37.5mm, 0mm), radius=0.25mm, height=6.85mm, segments=12)
  Dipole_154_R [pec] = cylinder(axis=X, base_centre=(22.75mm, 37.5mm, 0mm), radius=0.25mm, height=6.85mm, segments=12)
  PortSheet_154 = rectangle(corner=(22.25mm, 37.5mm, -0.5mm), z_size=0.5mm, x_size=1mm)
  Dipole_155_L [pec] = cylinder(axis=X, base_centre=(15.4mm, 52.5mm, 0mm), radius=0.25mm, height=6.85mm, segments=12)
  Dipole_155_R [pec] = cylinder(axis=X, base_centre=(22.75mm, 52.5mm, 0mm), radius=0.25mm, height=6.85mm, segments=12)
  PortSheet_155 = rectangle(corner=(22.25mm, 52.5mm, -0.5mm), z_size=0.5mm, x_size=1mm)
  Dipole_156_L [pec] = cylinder(axis=X, base_centre=(15.4mm, 67.5mm, 0mm), radius=0.25mm, height=6.85mm, segments=12)
  Dipole_156_R [pec] = cylinder(axis=X, base_centre=(22.75mm, 67.5mm, 0mm), radius=0.25mm, height=6.85mm, segments=12)
  PortSheet_156 = rectangle(corner=(22.25mm, 67.5mm, -0.5mm), z_size=0.5mm, x_size=1mm)
  Dipole_157_L [pec] = cylinder(axis=X, base_centre=(15.4mm, 82.5mm, 0mm), radius=0.25mm, height=6.85mm, segments=12)
  Dipole_157_R [pec] = cylinder(axis=X, base_centre=(22.75mm, 82.5mm, 0mm), radius=0.25mm, height=6.85mm, segments=12)
  PortSheet_157 = rectangle(corner=(22.25mm, 82.5mm, -0.5mm), z_size=0.5mm, x_size=1mm)
  Dipole_158_L [pec] = cylinder(axis=X, base_centre=(15.4mm, 97.5mm, 0mm), radius=0.25mm, height=6.85mm, segments=12)
  Dipole_158_R [pec] = cylinder(axis=X, base_centre=(22.75mm, 97.5mm, 0mm), radius=0.25mm, height=6.85mm, segments=12)
  PortSheet_158 = rectangle(corner=(22.25mm, 97.5mm, -0.5mm), z_size=0.5mm, x_size=1mm)
  Dipole_159_L [pec] = cylinder(axis=X, base_centre=(15.4mm, 112.5mm, 0mm), radius=0.25mm, height=6.85mm, segments=12)
  Dipole_159_R [pec] = cylinder(axis=X, base_centre=(22.75mm, 112.5mm, 0mm), radius=0.25mm, height=6.85mm, segments=12)
  PortSheet_159 = rectangle(corner=(22.25mm, 112.5mm, -0.5mm), z_size=0.5mm, x_size=1mm)
  Dipole_160_L [pec] = cylinder(axis=X, base_centre=(30.4mm, -112.5mm, 0mm), radius=0.25mm, height=6.85mm, segments=12)
  Dipole_160_R [pec] = cylinder(axis=X, base_centre=(37.75mm, -112.5mm, 0mm), radius=0.25mm, height=6.85mm, segments=12)
  PortSheet_160 = rectangle(corner=(37.25mm, -112.5mm, -0.5mm), z_size=0.5mm, x_size=1mm)
  Dipole_161_L [pec] = cylinder(axis=X, base_centre=(30.4mm, -97.5mm, 0mm), radius=0.25mm, height=6.85mm, segments=12)
  Dipole_161_R [pec] = cylinder(axis=X, base_centre=(37.75mm, -97.5mm, 0mm), radius=0.25mm, height=6.85mm, segments=12)
  PortSheet_161 = rectangle(corner=(37.25mm, -97.5mm, -0.5mm), z_size=0.5mm, x_size=1mm)
  Dipole_162_L [pec] = cylinder(axis=X, base_centre=(30.4mm, -82.5mm, 0mm), radius=0.25mm, height=6.85mm, segments=12)
  Dipole_162_R [pec] = cylinder(axis=X, base_centre=(37.75mm, -82.5mm, 0mm), radius=0.25mm, height=6.85mm, segments=12)
  PortSheet_162 = rectangle(corner=(37.25mm, -82.5mm, -0.5mm), z_size=0.5mm, x_size=1mm)
  Dipole_163_L [pec] = cylinder(axis=X, base_centre=(30.4mm, -67.5mm, 0mm), radius=0.25mm, height=6.85mm, segments=12)
  Dipole_163_R [pec] = cylinder(axis=X, base_centre=(37.75mm, -67.5mm, 0mm), radius=0.25mm, height=6.85mm, segments=12)
  PortSheet_163 = rectangle(corner=(37.25mm, -67.5mm, -0.5mm), z_size=0.5mm, x_size=1mm)
  Dipole_164_L [pec] = cylinder(axis=X, base_centre=(30.4mm, -52.5mm, 0mm), radius=0.25mm, height=6.85mm, segments=12)
  Dipole_164_R [pec] = cylinder(axis=X, base_centre=(37.75mm, -52.5mm, 0mm), radius=0.25mm, height=6.85mm, segments=12)
  PortSheet_164 = rectangle(corner=(37.25mm, -52.5mm, -0.5mm), z_size=0.5mm, x_size=1mm)
  Dipole_165_L [pec] = cylinder(axis=X, base_centre=(30.4mm, -37.5mm, 0mm), radius=0.25mm, height=6.85mm, segments=12)
  Dipole_165_R [pec] = cylinder(axis=X, base_centre=(37.75mm, -37.5mm, 0mm), radius=0.25mm, height=6.85mm, segments=12)
  PortSheet_165 = rectangle(corner=(37.25mm, -37.5mm, -0.5mm), z_size=0.5mm, x_size=1mm)
  Dipole_166_L [pec] = cylinder(axis=X, base_centre=(30.4mm, -22.5mm, 0mm), radius=0.25mm, height=6.85mm, segments=12)
  Dipole_166_R [pec] = cylinder(axis=X, base_centre=(37.75mm, -22.5mm, 0mm), radius=0.25mm, height=6.85mm, segments=12)
  PortSheet_166 = rectangle(corner=(37.25mm, -22.5mm, -0.5mm), z_size=0.5mm, x_size=1mm)
  Dipole_167_L [pec] = cylinder(axis=X, base_centre=(30.4mm, -7.5mm, 0mm), radius=0.25mm, height=6.85mm, segments=12)
  Dipole_167_R [pec] = cylinder(axis=X, base_centre=(37.75mm, -7.5mm, 0mm), radius=0.25mm, height=6.85mm, segments=12)
  PortSheet_167 = rectangle(corner=(37.25mm, -7.5mm, -0.5mm), z_size=0.5mm, x_size=1mm)
  Dipole_168_L [pec] = cylinder(axis=X, base_centre=(30.4mm, 7.5mm, 0mm), radius=0.25mm, height=6.85mm, segments=12)
  Dipole_168_R [pec] = cylinder(axis=X, base_centre=(37.75mm, 7.5mm, 0mm), radius=0.25mm, height=6.85mm, segments=12)
  PortSheet_168 = rectangle(corner=(37.25mm, 7.5mm, -0.5mm), z_size=0.5mm, x_size=1mm)
  Dipole_169_L [pec] = cylinder(axis=X, base_centre=(30.4mm, 22.5mm, 0mm), radius=0.25mm, height=6.85mm, segments=12)
  Dipole_169_R [pec] = cylinder(axis=X, base_centre=(37.75mm, 22.5mm, 0mm), radius=0.25mm, height=6.85mm, segments=12)
  PortSheet_169 = rectangle(corner=(37.25mm, 22.5mm, -0.5mm), z_size=0.5mm, x_size=1mm)
  Dipole_170_L [pec] = cylinder(axis=X, base_centre=(30.4mm, 37.5mm, 0mm), radius=0.25mm, height=6.85mm, segments=12)
  Dipole_170_R [pec] = cylinder(axis=X, base_centre=(37.75mm, 37.5mm, 0mm), radius=0.25mm, height=6.85mm, segments=12)
  PortSheet_170 = rectangle(corner=(37.25mm, 37.5mm, -0.5mm), z_size=0.5mm, x_size=1mm)
  Dipole_171_L [pec] = cylinder(axis=X, base_centre=(30.4mm, 52.5mm, 0mm), radius=0.25mm, height=6.85mm, segments=12)
  Dipole_171_R [pec] = cylinder(axis=X, base_centre=(37.75mm, 52.5mm, 0mm), radius=0.25mm, height=6.85mm, segments=12)
  PortSheet_171 = rectangle(corner=(37.25mm, 52.5mm, -0.5mm), z_size=0.5mm, x_size=1mm)
  Dipole_172_L [pec] = cylinder(axis=X, base_centre=(30.4mm, 67.5mm, 0mm), radius=0.25mm, height=6.85mm, segments=12)
  Dipole_172_R [pec] = cylinder(axis=X, base_centre=(37.75mm, 67.5mm, 0mm), radius=0.25mm, height=6.85mm, segments=12)
  PortSheet_172 = rectangle(corner=(37.25mm, 67.5mm, -0.5mm), z_size=0.5mm, x_size=1mm)
  Dipole_173_L [pec] = cylinder(axis=X, base_centre=(30.4mm, 82.5mm, 0mm), radius=0.25mm, height=6.85mm, segments=12)
  Dipole_173_R [pec] = cylinder(axis=X, base_centre=(37.75mm, 82.5mm, 0mm), radius=0.25mm, height=6.85mm, segments=12)
  PortSheet_173 = rectangle(corner=(37.25mm, 82.5mm, -0.5mm), z_size=0.5mm, x_size=1mm)
  Dipole_174_L [pec] = cylinder(axis=X, base_centre=(30.4mm, 97.5mm, 0mm), radius=0.25mm, height=6.85mm, segments=12)
  Dipole_174_R [pec] = cylinder(axis=X, base_centre=(37.75mm, 97.5mm, 0mm), radius=0.25mm, height=6.85mm, segments=12)
  PortSheet_174 = rectangle(corner=(37.25mm, 97.5mm, -0.5mm), z_size=0.5mm, x_size=1mm)
  Dipole_175_L [pec] = cylinder(axis=X, base_centre=(30.4mm, 112.5mm, 0mm), radius=0.25mm, height=6.85mm, segments=12)
  Dipole_175_R [pec] = cylinder(axis=X, base_centre=(37.75mm, 112.5mm, 0mm), radius=0.25mm, height=6.85mm, segments=12)
  PortSheet_175 = rectangle(corner=(37.25mm, 112.5mm, -0.5mm), z_size=0.5mm, x_size=1mm)
  Dipole_176_L [pec] = cylinder(axis=X, base_centre=(45.4mm, -112.5mm, 0mm), radius=0.25mm, height=6.85mm, segments=12)
  Dipole_176_R [pec] = cylinder(axis=X, base_centre=(52.75mm, -112.5mm, 0mm), radius=0.25mm, height=6.85mm, segments=12)
  PortSheet_176 = rectangle(corner=(52.25mm, -112.5mm, -0.5mm), z_size=0.5mm, x_size=1mm)
  Dipole_177_L [pec] = cylinder(axis=X, base_centre=(45.4mm, -97.5mm, 0mm), radius=0.25mm, height=6.85mm, segments=12)
  Dipole_177_R [pec] = cylinder(axis=X, base_centre=(52.75mm, -97.5mm, 0mm), radius=0.25mm, height=6.85mm, segments=12)
  PortSheet_177 = rectangle(corner=(52.25mm, -97.5mm, -0.5mm), z_size=0.5mm, x_size=1mm)
  Dipole_178_L [pec] = cylinder(axis=X, base_centre=(45.4mm, -82.5mm, 0mm), radius=0.25mm, height=6.85mm, segments=12)
  Dipole_178_R [pec] = cylinder(axis=X, base_centre=(52.75mm, -82.5mm, 0mm), radius=0.25mm, height=6.85mm, segments=12)
  PortSheet_178 = rectangle(corner=(52.25mm, -82.5mm, -0.5mm), z_size=0.5mm, x_size=1mm)
  Dipole_179_L [pec] = cylinder(axis=X, base_centre=(45.4mm, -67.5mm, 0mm), radius=0.25mm, height=6.85mm, segments=12)
  Dipole_179_R [pec] = cylinder(axis=X, base_centre=(52.75mm, -67.5mm, 0mm), radius=0.25mm, height=6.85mm, segments=12)
  PortSheet_179 = rectangle(corner=(52.25mm, -67.5mm, -0.5mm), z_size=0.5mm, x_size=1mm)
  Dipole_180_L [pec] = cylinder(axis=X, base_centre=(45.4mm, -52.5mm, 0mm), radius=0.25mm, height=6.85mm, segments=12)
  Dipole_180_R [pec] = cylinder(axis=X, base_centre=(52.75mm, -52.5mm, 0mm), radius=0.25mm, height=6.85mm, segments=12)
  PortSheet_180 = rectangle(corner=(52.25mm, -52.5mm, -0.5mm), z_size=0.5mm, x_size=1mm)
  Dipole_181_L [pec] = cylinder(axis=X, base_centre=(45.4mm, -37.5mm, 0mm), radius=0.25mm, height=6.85mm, segments=12)
  Dipole_181_R [pec] = cylinder(axis=X, base_centre=(52.75mm, -37.5mm, 0mm), radius=0.25mm, height=6.85mm, segments=12)
  PortSheet_181 = rectangle(corner=(52.25mm, -37.5mm, -0.5mm), z_size=0.5mm, x_size=1mm)
  Dipole_182_L [pec] = cylinder(axis=X, base_centre=(45.4mm, -22.5mm, 0mm), radius=0.25mm, height=6.85mm, segments=12)
  Dipole_182_R [pec] = cylinder(axis=X, base_centre=(52.75mm, -22.5mm, 0mm), radius=0.25mm, height=6.85mm, segments=12)
  PortSheet_182 = rectangle(corner=(52.25mm, -22.5mm, -0.5mm), z_size=0.5mm, x_size=1mm)
  Dipole_183_L [pec] = cylinder(axis=X, base_centre=(45.4mm, -7.5mm, 0mm), radius=0.25mm, height=6.85mm, segments=12)
  Dipole_183_R [pec] = cylinder(axis=X, base_centre=(52.75mm, -7.5mm, 0mm), radius=0.25mm, height=6.85mm, segments=12)
  PortSheet_183 = rectangle(corner=(52.25mm, -7.5mm, -0.5mm), z_size=0.5mm, x_size=1mm)
  Dipole_184_L [pec] = cylinder(axis=X, base_centre=(45.4mm, 7.5mm, 0mm), radius=0.25mm, height=6.85mm, segments=12)
  Dipole_184_R [pec] = cylinder(axis=X, base_centre=(52.75mm, 7.5mm, 0mm), radius=0.25mm, height=6.85mm, segments=12)
  PortSheet_184 = rectangle(corner=(52.25mm, 7.5mm, -0.5mm), z_size=0.5mm, x_size=1mm)
  Dipole_185_L [pec] = cylinder(axis=X, base_centre=(45.4mm, 22.5mm, 0mm), radius=0.25mm, height=6.85mm, segments=12)
  Dipole_185_R [pec] = cylinder(axis=X, base_centre=(52.75mm, 22.5mm, 0mm), radius=0.25mm, height=6.85mm, segments=12)
  PortSheet_185 = rectangle(corner=(52.25mm, 22.5mm, -0.5mm), z_size=0.5mm, x_size=1mm)
  Dipole_186_L [pec] = cylinder(axis=X, base_centre=(45.4mm, 37.5mm, 0mm), radius=0.25mm, height=6.85mm, segments=12)
  Dipole_186_R [pec] = cylinder(axis=X, base_centre=(52.75mm, 37.5mm, 0mm), radius=0.25mm, height=6.85mm, segments=12)
  PortSheet_186 = rectangle(corner=(52.25mm, 37.5mm, -0.5mm), z_size=0.5mm, x_size=1mm)
  Dipole_187_L [pec] = cylinder(axis=X, base_centre=(45.4mm, 52.5mm, 0mm), radius=0.25mm, height=6.85mm, segments=12)
  Dipole_187_R [pec] = cylinder(axis=X, base_centre=(52.75mm, 52.5mm, 0mm), radius=0.25mm, height=6.85mm, segments=12)
  PortSheet_187 = rectangle(corner=(52.25mm, 52.5mm, -0.5mm), z_size=0.5mm, x_size=1mm)
  Dipole_188_L [pec] = cylinder(axis=X, base_centre=(45.4mm, 67.5mm, 0mm), radius=0.25mm, height=6.85mm, segments=12)
  Dipole_188_R [pec] = cylinder(axis=X, base_centre=(52.75mm, 67.5mm, 0mm), radius=0.25mm, height=6.85mm, segments=12)
  PortSheet_188 = rectangle(corner=(52.25mm, 67.5mm, -0.5mm), z_size=0.5mm, x_size=1mm)
  Dipole_189_L [pec] = cylinder(axis=X, base_centre=(45.4mm, 82.5mm, 0mm), radius=0.25mm, height=6.85mm, segments=12)
  Dipole_189_R [pec] = cylinder(axis=X, base_centre=(52.75mm, 82.5mm, 0mm), radius=0.25mm, height=6.85mm, segments=12)
  PortSheet_189 = rectangle(corner=(52.25mm, 82.5mm, -0.5mm), z_size=0.5mm, x_size=1mm)
  Dipole_190_L [pec] = cylinder(axis=X, base_centre=(45.4mm, 97.5mm, 0mm), radius=0.25mm, height=6.85mm, segments=12)
  Dipole_190_R [pec] = cylinder(axis=X, base_centre=(52.75mm, 97.5mm, 0mm), radius=0.25mm, height=6.85mm, segments=12)
  PortSheet_190 = rectangle(corner=(52.25mm, 97.5mm, -0.5mm), z_size=0.5mm, x_size=1mm)
  Dipole_191_L [pec] = cylinder(axis=X, base_centre=(45.4mm, 112.5mm, 0mm), radius=0.25mm, height=6.85mm, segments=12)
  Dipole_191_R [pec] = cylinder(axis=X, base_centre=(52.75mm, 112.5mm, 0mm), radius=0.25mm, height=6.85mm, segments=12)
  PortSheet_191 = rectangle(corner=(52.25mm, 112.5mm, -0.5mm), z_size=0.5mm, x_size=1mm)
  Dipole_192_L [pec] = cylinder(axis=X, base_centre=(60.4mm, -112.5mm, 0mm), radius=0.25mm, height=6.85mm, segments=12)
  Dipole_192_R [pec] = cylinder(axis=X, base_centre=(67.75mm, -112.5mm, 0mm), radius=0.25mm, height=6.85mm, segments=12)
  PortSheet_192 = rectangle(corner=(67.25mm, -112.5mm, -0.5mm), z_size=0.5mm, x_size=1mm)
  Dipole_193_L [pec] = cylinder(axis=X, base_centre=(60.4mm, -97.5mm, 0mm), radius=0.25mm, height=6.85mm, segments=12)
  Dipole_193_R [pec] = cylinder(axis=X, base_centre=(67.75mm, -97.5mm, 0mm), radius=0.25mm, height=6.85mm, segments=12)
  PortSheet_193 = rectangle(corner=(67.25mm, -97.5mm, -0.5mm), z_size=0.5mm, x_size=1mm)
  Dipole_194_L [pec] = cylinder(axis=X, base_centre=(60.4mm, -82.5mm, 0mm), radius=0.25mm, height=6.85mm, segments=12)
  Dipole_194_R [pec] = cylinder(axis=X, base_centre=(67.75mm, -82.5mm, 0mm), radius=0.25mm, height=6.85mm, segments=12)
  PortSheet_194 = rectangle(corner=(67.25mm, -82.5mm, -0.5mm), z_size=0.5mm, x_size=1mm)
  Dipole_195_L [pec] = cylinder(axis=X, base_centre=(60.4mm, -67.5mm, 0mm), radius=0.25mm, height=6.85mm, segments=12)
  Dipole_195_R [pec] = cylinder(axis=X, base_centre=(67.75mm, -67.5mm, 0mm), radius=0.25mm, height=6.85mm, segments=12)
  PortSheet_195 = rectangle(corner=(67.25mm, -67.5mm, -0.5mm), z_size=0.5mm, x_size=1mm)
  Dipole_196_L [pec] = cylinder(axis=X, base_centre=(60.4mm, -52.5mm, 0mm), radius=0.25mm, height=6.85mm, segments=12)
  Dipole_196_R [pec] = cylinder(axis=X, base_centre=(67.75mm, -52.5mm, 0mm), radius=0.25mm, height=6.85mm, segments=12)
  PortSheet_196 = rectangle(corner=(67.25mm, -52.5mm, -0.5mm), z_size=0.5mm, x_size=1mm)
  Dipole_197_L [pec] = cylinder(axis=X, base_centre=(60.4mm, -37.5mm, 0mm), radius=0.25mm, height=6.85mm, segments=12)
  Dipole_197_R [pec] = cylinder(axis=X, base_centre=(67.75mm, -37.5mm, 0mm), radius=0.25mm, height=6.85mm, segments=12)
  PortSheet_197 = rectangle(corner=(67.25mm, -37.5mm, -0.5mm), z_size=0.5mm, x_size=1mm)
  Dipole_198_L [pec] = cylinder(axis=X, base_centre=(60.4mm, -22.5mm, 0mm), radius=0.25mm, height=6.85mm, segments=12)
  Dipole_198_R [pec] = cylinder(axis=X, base_centre=(67.75mm, -22.5mm, 0mm), radius=0.25mm, height=6.85mm, segments=12)
  PortSheet_198 = rectangle(corner=(67.25mm, -22.5mm, -0.5mm), z_size=0.5mm, x_size=1mm)
  Dipole_199_L [pec] = cylinder(axis=X, base_centre=(60.4mm, -7.5mm, 0mm), radius=0.25mm, height=6.85mm, segments=12)
  Dipole_199_R [pec] = cylinder(axis=X, base_centre=(67.75mm, -7.5mm, 0mm), radius=0.25mm, height=6.85mm, segments=12)
  PortSheet_199 = rectangle(corner=(67.25mm, -7.5mm, -0.5mm), z_size=0.5mm, x_size=1mm)
  Dipole_200_L [pec] = cylinder(axis=X, base_centre=(60.4mm, 7.5mm, 0mm), radius=0.25mm, height=6.85mm, segments=12)
  Dipole_200_R [pec] = cylinder(axis=X, base_centre=(67.75mm, 7.5mm, 0mm), radius=0.25mm, height=6.85mm, segments=12)
  PortSheet_200 = rectangle(corner=(67.25mm, 7.5mm, -0.5mm), z_size=0.5mm, x_size=1mm)
  Dipole_201_L [pec] = cylinder(axis=X, base_centre=(60.4mm, 22.5mm, 0mm), radius=0.25mm, height=6.85mm, segments=12)
  Dipole_201_R [pec] = cylinder(axis=X, base_centre=(67.75mm, 22.5mm, 0mm), radius=0.25mm, height=6.85mm, segments=12)
  PortSheet_201 = rectangle(corner=(67.25mm, 22.5mm, -0.5mm), z_size=0.5mm, x_size=1mm)
  Dipole_202_L [pec] = cylinder(axis=X, base_centre=(60.4mm, 37.5mm, 0mm), radius=0.25mm, height=6.85mm, segments=12)
  Dipole_202_R [pec] = cylinder(axis=X, base_centre=(67.75mm, 37.5mm, 0mm), radius=0.25mm, height=6.85mm, segments=12)
  PortSheet_202 = rectangle(corner=(67.25mm, 37.5mm, -0.5mm), z_size=0.5mm, x_size=1mm)
  Dipole_203_L [pec] = cylinder(axis=X, base_centre=(60.4mm, 52.5mm, 0mm), radius=0.25mm, height=6.85mm, segments=12)
  Dipole_203_R [pec] = cylinder(axis=X, base_centre=(67.75mm, 52.5mm, 0mm), radius=0.25mm, height=6.85mm, segments=12)
  PortSheet_203 = rectangle(corner=(67.25mm, 52.5mm, -0.5mm), z_size=0.5mm, x_size=1mm)
  Dipole_204_L [pec] = cylinder(axis=X, base_centre=(60.4mm, 67.5mm, 0mm), radius=0.25mm, height=6.85mm, segments=12)
  Dipole_204_R [pec] = cylinder(axis=X, base_centre=(67.75mm, 67.5mm, 0mm), radius=0.25mm, height=6.85mm, segments=12)
  PortSheet_204 = rectangle(corner=(67.25mm, 67.5mm, -0.5mm), z_size=0.5mm, x_size=1mm)
  Dipole_205_L [pec] = cylinder(axis=X, base_centre=(60.4mm, 82.5mm, 0mm), radius=0.25mm, height=6.85mm, segments=12)
  Dipole_205_R [pec] = cylinder(axis=X, base_centre=(67.75mm, 82.5mm, 0mm), radius=0.25mm, height=6.85mm, segments=12)
  PortSheet_205 = rectangle(corner=(67.25mm, 82.5mm, -0.5mm), z_size=0.5mm, x_size=1mm)
  Dipole_206_L [pec] = cylinder(axis=X, base_centre=(60.4mm, 97.5mm, 0mm), radius=0.25mm, height=6.85mm, segments=12)
  Dipole_206_R [pec] = cylinder(axis=X, base_centre=(67.75mm, 97.5mm, 0mm), radius=0.25mm, height=6.85mm, segments=12)
  PortSheet_206 = rectangle(corner=(67.25mm, 97.5mm, -0.5mm), z_size=0.5mm, x_size=1mm)
  Dipole_207_L [pec] = cylinder(axis=X, base_centre=(60.4mm, 112.5mm, 0mm), radius=0.25mm, height=6.85mm, segments=12)
  Dipole_207_R [pec] = cylinder(axis=X, base_centre=(67.75mm, 112.5mm, 0mm), radius=0.25mm, height=6.85mm, segments=12)
  PortSheet_207 = rectangle(corner=(67.25mm, 112.5mm, -0.5mm), z_size=0.5mm, x_size=1mm)
  Dipole_208_L [pec] = cylinder(axis=X, base_centre=(75.4mm, -112.5mm, 0mm), radius=0.25mm, height=6.85mm, segments=12)
  Dipole_208_R [pec] = cylinder(axis=X, base_centre=(82.75mm, -112.5mm, 0mm), radius=0.25mm, height=6.85mm, segments=12)
  PortSheet_208 = rectangle(corner=(82.25mm, -112.5mm, -0.5mm), z_size=0.5mm, x_size=1mm)
  Dipole_209_L [pec] = cylinder(axis=X, base_centre=(75.4mm, -97.5mm, 0mm), radius=0.25mm, height=6.85mm, segments=12)
  Dipole_209_R [pec] = cylinder(axis=X, base_centre=(82.75mm, -97.5mm, 0mm), radius=0.25mm, height=6.85mm, segments=12)
  PortSheet_209 = rectangle(corner=(82.25mm, -97.5mm, -0.5mm), z_size=0.5mm, x_size=1mm)
  Dipole_210_L [pec] = cylinder(axis=X, base_centre=(75.4mm, -82.5mm, 0mm), radius=0.25mm, height=6.85mm, segments=12)
  Dipole_210_R [pec] = cylinder(axis=X, base_centre=(82.75mm, -82.5mm, 0mm), radius=0.25mm, height=6.85mm, segments=12)
  PortSheet_210 = rectangle(corner=(82.25mm, -82.5mm, -0.5mm), z_size=0.5mm, x_size=1mm)
  Dipole_211_L [pec] = cylinder(axis=X, base_centre=(75.4mm, -67.5mm, 0mm), radius=0.25mm, height=6.85mm, segments=12)
  Dipole_211_R [pec] = cylinder(axis=X, base_centre=(82.75mm, -67.5mm, 0mm), radius=0.25mm, height=6.85mm, segments=12)
  PortSheet_211 = rectangle(corner=(82.25mm, -67.5mm, -0.5mm), z_size=0.5mm, x_size=1mm)
  Dipole_212_L [pec] = cylinder(axis=X, base_centre=(75.4mm, -52.5mm, 0mm), radius=0.25mm, height=6.85mm, segments=12)
  Dipole_212_R [pec] = cylinder(axis=X, base_centre=(82.75mm, -52.5mm, 0mm), radius=0.25mm, height=6.85mm, segments=12)
  PortSheet_212 = rectangle(corner=(82.25mm, -52.5mm, -0.5mm), z_size=0.5mm, x_size=1mm)
  Dipole_213_L [pec] = cylinder(axis=X, base_centre=(75.4mm, -37.5mm, 0mm), radius=0.25mm, height=6.85mm, segments=12)
  Dipole_213_R [pec] = cylinder(axis=X, base_centre=(82.75mm, -37.5mm, 0mm), radius=0.25mm, height=6.85mm, segments=12)
  PortSheet_213 = rectangle(corner=(82.25mm, -37.5mm, -0.5mm), z_size=0.5mm, x_size=1mm)
  Dipole_214_L [pec] = cylinder(axis=X, base_centre=(75.4mm, -22.5mm, 0mm), radius=0.25mm, height=6.85mm, segments=12)
  Dipole_214_R [pec] = cylinder(axis=X, base_centre=(82.75mm, -22.5mm, 0mm), radius=0.25mm, height=6.85mm, segments=12)
  PortSheet_214 = rectangle(corner=(82.25mm, -22.5mm, -0.5mm), z_size=0.5mm, x_size=1mm)
  Dipole_215_L [pec] = cylinder(axis=X, base_centre=(75.4mm, -7.5mm, 0mm), radius=0.25mm, height=6.85mm, segments=12)
  Dipole_215_R [pec] = cylinder(axis=X, base_centre=(82.75mm, -7.5mm, 0mm), radius=0.25mm, height=6.85mm, segments=12)
  PortSheet_215 = rectangle(corner=(82.25mm, -7.5mm, -0.5mm), z_size=0.5mm, x_size=1mm)
  Dipole_216_L [pec] = cylinder(axis=X, base_centre=(75.4mm, 7.5mm, 0mm), radius=0.25mm, height=6.85mm, segments=12)
  Dipole_216_R [pec] = cylinder(axis=X, base_centre=(82.75mm, 7.5mm, 0mm), radius=0.25mm, height=6.85mm, segments=12)
  PortSheet_216 = rectangle(corner=(82.25mm, 7.5mm, -0.5mm), z_size=0.5mm, x_size=1mm)
  Dipole_217_L [pec] = cylinder(axis=X, base_centre=(75.4mm, 22.5mm, 0mm), radius=0.25mm, height=6.85mm, segments=12)
  Dipole_217_R [pec] = cylinder(axis=X, base_centre=(82.75mm, 22.5mm, 0mm), radius=0.25mm, height=6.85mm, segments=12)
  PortSheet_217 = rectangle(corner=(82.25mm, 22.5mm, -0.5mm), z_size=0.5mm, x_size=1mm)
  Dipole_218_L [pec] = cylinder(axis=X, base_centre=(75.4mm, 37.5mm, 0mm), radius=0.25mm, height=6.85mm, segments=12)
  Dipole_218_R [pec] = cylinder(axis=X, base_centre=(82.75mm, 37.5mm, 0mm), radius=0.25mm, height=6.85mm, segments=12)
  PortSheet_218 = rectangle(corner=(82.25mm, 37.5mm, -0.5mm), z_size=0.5mm, x_size=1mm)
  Dipole_219_L [pec] = cylinder(axis=X, base_centre=(75.4mm, 52.5mm, 0mm), radius=0.25mm, height=6.85mm, segments=12)
  Dipole_219_R [pec] = cylinder(axis=X, base_centre=(82.75mm, 52.5mm, 0mm), radius=0.25mm, height=6.85mm, segments=12)
  PortSheet_219 = rectangle(corner=(82.25mm, 52.5mm, -0.5mm), z_size=0.5mm, x_size=1mm)
  Dipole_220_L [pec] = cylinder(axis=X, base_centre=(75.4mm, 67.5mm, 0mm), radius=0.25mm, height=6.85mm, segments=12)
  Dipole_220_R [pec] = cylinder(axis=X, base_centre=(82.75mm, 67.5mm, 0mm), radius=0.25mm, height=6.85mm, segments=12)
  PortSheet_220 = rectangle(corner=(82.25mm, 67.5mm, -0.5mm), z_size=0.5mm, x_size=1mm)
  Dipole_221_L [pec] = cylinder(axis=X, base_centre=(75.4mm, 82.5mm, 0mm), radius=0.25mm, height=6.85mm, segments=12)
  Dipole_221_R [pec] = cylinder(axis=X, base_centre=(82.75mm, 82.5mm, 0mm), radius=0.25mm, height=6.85mm, segments=12)
  PortSheet_221 = rectangle(corner=(82.25mm, 82.5mm, -0.5mm), z_size=0.5mm, x_size=1mm)
  Dipole_222_L [pec] = cylinder(axis=X, base_centre=(75.4mm, 97.5mm, 0mm), radius=0.25mm, height=6.85mm, segments=12)
  Dipole_222_R [pec] = cylinder(axis=X, base_centre=(82.75mm, 97.5mm, 0mm), radius=0.25mm, height=6.85mm, segments=12)
  PortSheet_222 = rectangle(corner=(82.25mm, 97.5mm, -0.5mm), z_size=0.5mm, x_size=1mm)
  Dipole_223_L [pec] = cylinder(axis=X, base_centre=(75.4mm, 112.5mm, 0mm), radius=0.25mm, height=6.85mm, segments=12)
  Dipole_223_R [pec] = cylinder(axis=X, base_centre=(82.75mm, 112.5mm, 0mm), radius=0.25mm, height=6.85mm, segments=12)
  PortSheet_223 = rectangle(corner=(82.25mm, 112.5mm, -0.5mm), z_size=0.5mm, x_size=1mm)
  Dipole_224_L [pec] = cylinder(axis=X, base_centre=(90.4mm, -112.5mm, 0mm), radius=0.25mm, height=6.85mm, segments=12)
  Dipole_224_R [pec] = cylinder(axis=X, base_centre=(97.75mm, -112.5mm, 0mm), radius=0.25mm, height=6.85mm, segments=12)
  PortSheet_224 = rectangle(corner=(97.25mm, -112.5mm, -0.5mm), z_size=0.5mm, x_size=1mm)
  Dipole_225_L [pec] = cylinder(axis=X, base_centre=(90.4mm, -97.5mm, 0mm), radius=0.25mm, height=6.85mm, segments=12)
  Dipole_225_R [pec] = cylinder(axis=X, base_centre=(97.75mm, -97.5mm, 0mm), radius=0.25mm, height=6.85mm, segments=12)
  PortSheet_225 = rectangle(corner=(97.25mm, -97.5mm, -0.5mm), z_size=0.5mm, x_size=1mm)
  Dipole_226_L [pec] = cylinder(axis=X, base_centre=(90.4mm, -82.5mm, 0mm), radius=0.25mm, height=6.85mm, segments=12)
  Dipole_226_R [pec] = cylinder(axis=X, base_centre=(97.75mm, -82.5mm, 0mm), radius=0.25mm, height=6.85mm, segments=12)
  PortSheet_226 = rectangle(corner=(97.25mm, -82.5mm, -0.5mm), z_size=0.5mm, x_size=1mm)
  Dipole_227_L [pec] = cylinder(axis=X, base_centre=(90.4mm, -67.5mm, 0mm), radius=0.25mm, height=6.85mm, segments=12)
  Dipole_227_R [pec] = cylinder(axis=X, base_centre=(97.75mm, -67.5mm, 0mm), radius=0.25mm, height=6.85mm, segments=12)
  PortSheet_227 = rectangle(corner=(97.25mm, -67.5mm, -0.5mm), z_size=0.5mm, x_size=1mm)
  Dipole_228_L [pec] = cylinder(axis=X, base_centre=(90.4mm, -52.5mm, 0mm), radius=0.25mm, height=6.85mm, segments=12)
  Dipole_228_R [pec] = cylinder(axis=X, base_centre=(97.75mm, -52.5mm, 0mm), radius=0.25mm, height=6.85mm, segments=12)
  PortSheet_228 = rectangle(corner=(97.25mm, -52.5mm, -0.5mm), z_size=0.5mm, x_size=1mm)
  Dipole_229_L [pec] = cylinder(axis=X, base_centre=(90.4mm, -37.5mm, 0mm), radius=0.25mm, height=6.85mm, segments=12)
  Dipole_229_R [pec] = cylinder(axis=X, base_centre=(97.75mm, -37.5mm, 0mm), radius=0.25mm, height=6.85mm, segments=12)
  PortSheet_229 = rectangle(corner=(97.25mm, -37.5mm, -0.5mm), z_size=0.5mm, x_size=1mm)
  Dipole_230_L [pec] = cylinder(axis=X, base_centre=(90.4mm, -22.5mm, 0mm), radius=0.25mm, height=6.85mm, segments=12)
  Dipole_230_R [pec] = cylinder(axis=X, base_centre=(97.75mm, -22.5mm, 0mm), radius=0.25mm, height=6.85mm, segments=12)
  PortSheet_230 = rectangle(corner=(97.25mm, -22.5mm, -0.5mm), z_size=0.5mm, x_size=1mm)
  Dipole_231_L [pec] = cylinder(axis=X, base_centre=(90.4mm, -7.5mm, 0mm), radius=0.25mm, height=6.85mm, segments=12)
  Dipole_231_R [pec] = cylinder(axis=X, base_centre=(97.75mm, -7.5mm, 0mm), radius=0.25mm, height=6.85mm, segments=12)
  PortSheet_231 = rectangle(corner=(97.25mm, -7.5mm, -0.5mm), z_size=0.5mm, x_size=1mm)
  Dipole_232_L [pec] = cylinder(axis=X, base_centre=(90.4mm, 7.5mm, 0mm), radius=0.25mm, height=6.85mm, segments=12)
  Dipole_232_R [pec] = cylinder(axis=X, base_centre=(97.75mm, 7.5mm, 0mm), radius=0.25mm, height=6.85mm, segments=12)
  PortSheet_232 = rectangle(corner=(97.25mm, 7.5mm, -0.5mm), z_size=0.5mm, x_size=1mm)
  Dipole_233_L [pec] = cylinder(axis=X, base_centre=(90.4mm, 22.5mm, 0mm), radius=0.25mm, height=6.85mm, segments=12)
  Dipole_233_R [pec] = cylinder(axis=X, base_centre=(97.75mm, 22.5mm, 0mm), radius=0.25mm, height=6.85mm, segments=12)
  PortSheet_233 = rectangle(corner=(97.25mm, 22.5mm, -0.5mm), z_size=0.5mm, x_size=1mm)
  Dipole_234_L [pec] = cylinder(axis=X, base_centre=(90.4mm, 37.5mm, 0mm), radius=0.25mm, height=6.85mm, segments=12)
  Dipole_234_R [pec] = cylinder(axis=X, base_centre=(97.75mm, 37.5mm, 0mm), radius=0.25mm, height=6.85mm, segments=12)
  PortSheet_234 = rectangle(corner=(97.25mm, 37.5mm, -0.5mm), z_size=0.5mm, x_size=1mm)
  Dipole_235_L [pec] = cylinder(axis=X, base_centre=(90.4mm, 52.5mm, 0mm), radius=0.25mm, height=6.85mm, segments=12)
  Dipole_235_R [pec] = cylinder(axis=X, base_centre=(97.75mm, 52.5mm, 0mm), radius=0.25mm, height=6.85mm, segments=12)
  PortSheet_235 = rectangle(corner=(97.25mm, 52.5mm, -0.5mm), z_size=0.5mm, x_size=1mm)
  Dipole_236_L [pec] = cylinder(axis=X, base_centre=(90.4mm, 67.5mm, 0mm), radius=0.25mm, height=6.85mm, segments=12)
  Dipole_236_R [pec] = cylinder(axis=X, base_centre=(97.75mm, 67.5mm, 0mm), radius=0.25mm, height=6.85mm, segments=12)
  PortSheet_236 = rectangle(corner=(97.25mm, 67.5mm, -0.5mm), z_size=0.5mm, x_size=1mm)
  Dipole_237_L [pec] = cylinder(axis=X, base_centre=(90.4mm, 82.5mm, 0mm), radius=0.25mm, height=6.85mm, segments=12)
  Dipole_237_R [pec] = cylinder(axis=X, base_centre=(97.75mm, 82.5mm, 0mm), radius=0.25mm, height=6.85mm, segments=12)
  PortSheet_237 = rectangle(corner=(97.25mm, 82.5mm, -0.5mm), z_size=0.5mm, x_size=1mm)
  Dipole_238_L [pec] = cylinder(axis=X, base_centre=(90.4mm, 97.5mm, 0mm), radius=0.25mm, height=6.85mm, segments=12)
  Dipole_238_R [pec] = cylinder(axis=X, base_centre=(97.75mm, 97.5mm, 0mm), radius=0.25mm, height=6.85mm, segments=12)
  PortSheet_238 = rectangle(corner=(97.25mm, 97.5mm, -0.5mm), z_size=0.5mm, x_size=1mm)
  Dipole_239_L [pec] = cylinder(axis=X, base_centre=(90.4mm, 112.5mm, 0mm), radius=0.25mm, height=6.85mm, segments=12)
  Dipole_239_R [pec] = cylinder(axis=X, base_centre=(97.75mm, 112.5mm, 0mm), radius=0.25mm, height=6.85mm, segments=12)
  PortSheet_239 = rectangle(corner=(97.25mm, 112.5mm, -0.5mm), z_size=0.5mm, x_size=1mm)
  Dipole_240_L [pec] = cylinder(axis=X, base_centre=(105.4mm, -112.5mm, 0mm), radius=0.25mm, height=6.85mm, segments=12)
  Dipole_240_R [pec] = cylinder(axis=X, base_centre=(112.75mm, -112.5mm, 0mm), radius=0.25mm, height=6.85mm, segments=12)
  PortSheet_240 = rectangle(corner=(112.25mm, -112.5mm, -0.5mm), z_size=0.5mm, x_size=1mm)
  Dipole_241_L [pec] = cylinder(axis=X, base_centre=(105.4mm, -97.5mm, 0mm), radius=0.25mm, height=6.85mm, segments=12)
  Dipole_241_R [pec] = cylinder(axis=X, base_centre=(112.75mm, -97.5mm, 0mm), radius=0.25mm, height=6.85mm, segments=12)
  PortSheet_241 = rectangle(corner=(112.25mm, -97.5mm, -0.5mm), z_size=0.5mm, x_size=1mm)
  Dipole_242_L [pec] = cylinder(axis=X, base_centre=(105.4mm, -82.5mm, 0mm), radius=0.25mm, height=6.85mm, segments=12)
  Dipole_242_R [pec] = cylinder(axis=X, base_centre=(112.75mm, -82.5mm, 0mm), radius=0.25mm, height=6.85mm, segments=12)
  PortSheet_242 = rectangle(corner=(112.25mm, -82.5mm, -0.5mm), z_size=0.5mm, x_size=1mm)
  Dipole_243_L [pec] = cylinder(axis=X, base_centre=(105.4mm, -67.5mm, 0mm), radius=0.25mm, height=6.85mm, segments=12)
  Dipole_243_R [pec] = cylinder(axis=X, base_centre=(112.75mm, -67.5mm, 0mm), radius=0.25mm, height=6.85mm, segments=12)
  PortSheet_243 = rectangle(corner=(112.25mm, -67.5mm, -0.5mm), z_size=0.5mm, x_size=1mm)
  Dipole_244_L [pec] = cylinder(axis=X, base_centre=(105.4mm, -52.5mm, 0mm), radius=0.25mm, height=6.85mm, segments=12)
  Dipole_244_R [pec] = cylinder(axis=X, base_centre=(112.75mm, -52.5mm, 0mm), radius=0.25mm, height=6.85mm, segments=12)
  PortSheet_244 = rectangle(corner=(112.25mm, -52.5mm, -0.5mm), z_size=0.5mm, x_size=1mm)
  Dipole_245_L [pec] = cylinder(axis=X, base_centre=(105.4mm, -37.5mm, 0mm), radius=0.25mm, height=6.85mm, segments=12)
  Dipole_245_R [pec] = cylinder(axis=X, base_centre=(112.75mm, -37.5mm, 0mm), radius=0.25mm, height=6.85mm, segments=12)
  PortSheet_245 = rectangle(corner=(112.25mm, -37.5mm, -0.5mm), z_size=0.5mm, x_size=1mm)
  Dipole_246_L [pec] = cylinder(axis=X, base_centre=(105.4mm, -22.5mm, 0mm), radius=0.25mm, height=6.85mm, segments=12)
  Dipole_246_R [pec] = cylinder(axis=X, base_centre=(112.75mm, -22.5mm, 0mm), radius=0.25mm, height=6.85mm, segments=12)
  PortSheet_246 = rectangle(corner=(112.25mm, -22.5mm, -0.5mm), z_size=0.5mm, x_size=1mm)
  Dipole_247_L [pec] = cylinder(axis=X, base_centre=(105.4mm, -7.5mm, 0mm), radius=0.25mm, height=6.85mm, segments=12)
  Dipole_247_R [pec] = cylinder(axis=X, base_centre=(112.75mm, -7.5mm, 0mm), radius=0.25mm, height=6.85mm, segments=12)
  PortSheet_247 = rectangle(corner=(112.25mm, -7.5mm, -0.5mm), z_size=0.5mm, x_size=1mm)
  Dipole_248_L [pec] = cylinder(axis=X, base_centre=(105.4mm, 7.5mm, 0mm), radius=0.25mm, height=6.85mm, segments=12)
  Dipole_248_R [pec] = cylinder(axis=X, base_centre=(112.75mm, 7.5mm, 0mm), radius=0.25mm, height=6.85mm, segments=12)
  PortSheet_248 = rectangle(corner=(112.25mm, 7.5mm, -0.5mm), z_size=0.5mm, x_size=1mm)
  Dipole_249_L [pec] = cylinder(axis=X, base_centre=(105.4mm, 22.5mm, 0mm), radius=0.25mm, height=6.85mm, segments=12)
  Dipole_249_R [pec] = cylinder(axis=X, base_centre=(112.75mm, 22.5mm, 0mm), radius=0.25mm, height=6.85mm, segments=12)
  PortSheet_249 = rectangle(corner=(112.25mm, 22.5mm, -0.5mm), z_size=0.5mm, x_size=1mm)
  Dipole_250_L [pec] = cylinder(axis=X, base_centre=(105.4mm, 37.5mm, 0mm), radius=0.25mm, height=6.85mm, segments=12)
  Dipole_250_R [pec] = cylinder(axis=X, base_centre=(112.75mm, 37.5mm, 0mm), radius=0.25mm, height=6.85mm, segments=12)
  PortSheet_250 = rectangle(corner=(112.25mm, 37.5mm, -0.5mm), z_size=0.5mm, x_size=1mm)
  Dipole_251_L [pec] = cylinder(axis=X, base_centre=(105.4mm, 52.5mm, 0mm), radius=0.25mm, height=6.85mm, segments=12)
  Dipole_251_R [pec] = cylinder(axis=X, base_centre=(112.75mm, 52.5mm, 0mm), radius=0.25mm, height=6.85mm, segments=12)
  PortSheet_251 = rectangle(corner=(112.25mm, 52.5mm, -0.5mm), z_size=0.5mm, x_size=1mm)
  Dipole_252_L [pec] = cylinder(axis=X, base_centre=(105.4mm, 67.5mm, 0mm), radius=0.25mm, height=6.85mm, segments=12)
  Dipole_252_R [pec] = cylinder(axis=X, base_centre=(112.75mm, 67.5mm, 0mm), radius=0.25mm, height=6.85mm, segments=12)
  PortSheet_252 = rectangle(corner=(112.25mm, 67.5mm, -0.5mm), z_size=0.5mm, x_size=1mm)
  Dipole_253_L [pec] = cylinder(axis=X, base_centre=(105.4mm, 82.5mm, 0mm), radius=0.25mm, height=6.85mm, segments=12)
  Dipole_253_R [pec] = cylinder(axis=X, base_centre=(112.75mm, 82.5mm, 0mm), radius=0.25mm, height=6.85mm, segments=12)
  PortSheet_253 = rectangle(corner=(112.25mm, 82.5mm, -0.5mm), z_size=0.5mm, x_size=1mm)
  Dipole_254_L [pec] = cylinder(axis=X, base_centre=(105.4mm, 97.5mm, 0mm), radius=0.25mm, height=6.85mm, segments=12)
  Dipole_254_R [pec] = cylinder(axis=X, base_centre=(112.75mm, 97.5mm, 0mm), radius=0.25mm, height=6.85mm, segments=12)
  PortSheet_254 = rectangle(corner=(112.25mm, 97.5mm, -0.5mm), z_size=0.5mm, x_size=1mm)
  Dipole_255_L [pec] = cylinder(axis=X, base_centre=(105.4mm, 112.5mm, 0mm), radius=0.25mm, height=6.85mm, segments=12)
  Dipole_255_R [pec] = cylinder(axis=X, base_centre=(112.75mm, 112.5mm, 0mm), radius=0.25mm, height=6.85mm, segments=12)
  PortSheet_255 = rectangle(corner=(112.25mm, 112.5mm, -0.5mm), z_size=0.5mm, x_size=1mm)
boundaries and excitations:
  Rad_AirRegion: Radiation Objects=AirRegion
  P000: Lumped Port Objects=PortSheet_000 LumpedPortType=Modal Modes{Mode1{IntLine{(-112.75, -112.5, 0) -> (-112.25, -112.5, 0)} CharImp=Zpi}} Impedance=50ohm
  P001: Lumped Port Objects=PortSheet_001 LumpedPortType=Modal Modes{Mode1{IntLine{(-112.75, -97.5, 0) -> (-112.25, -97.5, 0)} CharImp=Zpi}} Impedance=50ohm
  P002: Lumped Port Objects=PortSheet_002 LumpedPortType=Modal Modes{Mode1{IntLine{(-112.75, -82.5, 0) -> (-112.25, -82.5, 0)} CharImp=Zpi}} Impedance=50ohm
  P003: Lumped Port Objects=PortSheet_003 LumpedPortType=Modal Modes{Mode1{IntLine{(-112.75, -67.5, 0) -> (-112.25, -67.5, 0)} CharImp=Zpi}} Impedance=50ohm
  P004: Lumped Port Objects=PortSheet_004 LumpedPortType=Modal Modes{Mode1{IntLine{(-112.75, -52.5, 0) -> (-112.25, -52.5, 0)} CharImp=Zpi}} Impedance=50ohm
  P005: Lumped Port Objects=PortSheet_005 LumpedPortType=Modal Modes{Mode1{IntLine{(-112.75, -37.5, 0) -> (-112.25, -37.5, 0)} CharImp=Zpi}} Impedance=50ohm
  P006: Lumped Port Objects=PortSheet_006 LumpedPortType=Modal Modes{Mode1{IntLine{(-112.75, -22.5, 0) -> (-112.25, -22.5, 0)} CharImp=Zpi}} Impedance=50ohm
  P007: Lumped Port Objects=PortSheet_007 LumpedPortType=Modal Modes{Mode1{IntLine{(-112.75, -7.5, 0) -> (-112.25, -7.5, 0)} CharImp=Zpi}} Impedance=50ohm
  P008: Lumped Port Objects=PortSheet_008 LumpedPortType=Modal Modes{Mode1{IntLine{(-112.75, 7.5, 0) -> (-112.25, 7.5, 0)} CharImp=Zpi}} Impedance=50ohm
  P009: Lumped Port Objects=PortSheet_009 LumpedPortType=Modal Modes{Mode1{IntLine{(-112.75, 22.5, 0) -> (-112.25, 22.5, 0)} CharImp=Zpi}} Impedance=50ohm
  P010: Lumped Port Objects=PortSheet_010 LumpedPortType=Modal Modes{Mode1{IntLine{(-112.75, 37.5, 0) -> (-112.25, 37.5, 0)} CharImp=Zpi}} Impedance=50ohm
  P011: Lumped Port Objects=PortSheet_011 LumpedPortType=Modal Modes{Mode1{IntLine{(-112.75, 52.5, 0) -> (-112.25, 52.5, 0)} CharImp=Zpi}} Impedance=50ohm
  P012: Lumped Port Objects=PortSheet_012 LumpedPortType=Modal Modes{Mode1{IntLine{(-112.75, 67.5, 0) -> (-112.25, 67.5, 0)} CharImp=Zpi}} Impedance=50ohm
  P013: Lumped Port Objects=PortSheet_013 LumpedPortType=Modal Modes{Mode1{IntLine{(-112.75, 82.5, 0) -> (-112.25, 82.5, 0)} CharImp=Zpi}} Impedance=50ohm
  P014: Lumped Port Objects=PortSheet_014 LumpedPortType=Modal Modes{Mode1{IntLine{(-112.75, 97.5, 0) -> (-112.25, 97.5, 0)} CharImp=Zpi}} Impedance=50ohm
  P015: Lumped Port Objects=PortSheet_015 LumpedPortType=Modal Modes{Mode1{IntLine{(-112.75, 112.5, 0) -> (-112.25, 112.5, 0)} CharImp=Zpi}} Impedance=50ohm
  P016: Lumped Port Objects=PortSheet_016 LumpedPortType=Modal Modes{Mode1{IntLine{(-97.75, -112.5, 0) -> (-97.25, -112.5, 0)} CharImp=Zpi}} Impedance=50ohm
  P017: Lumped Port Objects=PortSheet_017 LumpedPortType=Modal Modes{Mode1{IntLine{(-97.75, -97.5, 0) -> (-97.25, -97.5, 0)} CharImp=Zpi}} Impedance=50ohm
  P018: Lumped Port Objects=PortSheet_018 LumpedPortType=Modal Modes{Mode1{IntLine{(-97.75, -82.5, 0) -> (-97.25, -82.5, 0)} CharImp=Zpi}} Impedance=50ohm
  P019: Lumped Port Objects=PortSheet_019 LumpedPortType=Modal Modes{Mode1{IntLine{(-97.75, -67.5, 0) -> (-97.25, -67.5, 0)} CharImp=Zpi}} Impedance=50ohm
  P020: Lumped Port Objects=PortSheet_020 LumpedPortType=Modal Modes{Mode1{IntLine{(-97.75, -52.5, 0) -> (-97.25, -52.5, 0)} CharImp=Zpi}} Impedance=50ohm
  P021: Lumped Port Objects=PortSheet_021 LumpedPortType=Modal Modes{Mode1{IntLine{(-97.75, -37.5, 0) -> (-97.25, -37.5, 0)} CharImp=Zpi}} Impedance=50ohm
  P022: Lumped Port Objects=PortSheet_022 LumpedPortType=Modal Modes{Mode1{IntLine{(-97.75, -22.5, 0) -> (-97.25, -22.5, 0)} CharImp=Zpi}} Impedance=50ohm
  P023: Lumped Port Objects=PortSheet_023 LumpedPortType=Modal Modes{Mode1{IntLine{(-97.75, -7.5, 0) -> (-97.25, -7.5, 0)} CharImp=Zpi}} Impedance=50ohm
  P024: Lumped Port Objects=PortSheet_024 LumpedPortType=Modal Modes{Mode1{IntLine{(-97.75, 7.5, 0) -> (-97.25, 7.5, 0)} CharImp=Zpi}} Impedance=50ohm
  P025: Lumped Port Objects=PortSheet_025 LumpedPortType=Modal Modes{Mode1{IntLine{(-97.75, 22.5, 0) -> (-97.25, 22.5, 0)} CharImp=Zpi}} Impedance=50ohm
  P026: Lumped Port Objects=PortSheet_026 LumpedPortType=Modal Modes{Mode1{IntLine{(-97.75, 37.5, 0) -> (-97.25, 37.5, 0)} CharImp=Zpi}} Impedance=50ohm
  P027: Lumped Port Objects=PortSheet_027 LumpedPortType=Modal Modes{Mode1{IntLine{(-97.75, 52.5, 0) -> (-97.25, 52.5, 0)} CharImp=Zpi}} Impedance=50ohm
  P028: Lumped Port Objects=PortSheet_028 LumpedPortType=Modal Modes{Mode1{IntLine{(-97.75, 67.5, 0) -> (-97.25, 67.5, 0)} CharImp=Zpi}} Impedance=50ohm
  P029: Lumped Port Objects=PortSheet_029 LumpedPortType=Modal Modes{Mode1{IntLine{(-97.75, 82.5, 0) -> (-97.25, 82.5, 0)} CharImp=Zpi}} Impedance=50ohm
  P030: Lumped Port Objects=PortSheet_030 LumpedPortType=Modal Modes{Mode1{IntLine{(-97.75, 97.5, 0) -> (-97.25, 97.5, 0)} CharImp=Zpi}} Impedance=50ohm
  P031: Lumped Port Objects=PortSheet_031 LumpedPortType=Modal Modes{Mode1{IntLine{(-97.75, 112.5, 0) -> (-97.25, 112.5, 0)} CharImp=Zpi}} Impedance=50ohm
  P032: Lumped Port Objects=PortSheet_032 LumpedPortType=Modal Modes{Mode1{IntLine{(-82.75, -112.5, 0) -> (-82.25, -112.5, 0)} CharImp=Zpi}} Impedance=50ohm
  P033: Lumped Port Objects=PortSheet_033 LumpedPortType=Modal Modes{Mode1{IntLine{(-82.75, -97.5, 0) -> (-82.25, -97.5, 0)} CharImp=Zpi}} Impedance=50ohm
  P034: Lumped Port Objects=PortSheet_034 LumpedPortType=Modal Modes{Mode1{IntLine{(-82.75, -82.5, 0) -> (-82.25, -82.5, 0)} CharImp=Zpi}} Impedance=50ohm
  P035: Lumped Port Objects=PortSheet_035 LumpedPortType=Modal Modes{Mode1{IntLine{(-82.75, -67.5, 0) -> (-82.25, -67.5, 0)} CharImp=Zpi}} Impedance=50ohm
  P036: Lumped Port Objects=PortSheet_036 LumpedPortType=Modal Modes{Mode1{IntLine{(-82.75, -52.5, 0) -> (-82.25, -52.5, 0)} CharImp=Zpi}} Impedance=50ohm
  P037: Lumped Port Objects=PortSheet_037 LumpedPortType=Modal Modes{Mode1{IntLine{(-82.75, -37.5, 0) -> (-82.25, -37.5, 0)} CharImp=Zpi}} Impedance=50ohm
  P038: Lumped Port Objects=PortSheet_038 LumpedPortType=Modal Modes{Mode1{IntLine{(-82.75, -22.5, 0) -> (-82.25, -22.5, 0)} CharImp=Zpi}} Impedance=50ohm
  P039: Lumped Port Objects=PortSheet_039 LumpedPortType=Modal Modes{Mode1{IntLine{(-82.75, -7.5, 0) -> (-82.25, -7.5, 0)} CharImp=Zpi}} Impedance=50ohm
  P040: Lumped Port Objects=PortSheet_040 LumpedPortType=Modal Modes{Mode1{IntLine{(-82.75, 7.5, 0) -> (-82.25, 7.5, 0)} CharImp=Zpi}} Impedance=50ohm
  P041: Lumped Port Objects=PortSheet_041 LumpedPortType=Modal Modes{Mode1{IntLine{(-82.75, 22.5, 0) -> (-82.25, 22.5, 0)} CharImp=Zpi}} Impedance=50ohm
  P042: Lumped Port Objects=PortSheet_042 LumpedPortType=Modal Modes{Mode1{IntLine{(-82.75, 37.5, 0) -> (-82.25, 37.5, 0)} CharImp=Zpi}} Impedance=50ohm
  P043: Lumped Port Objects=PortSheet_043 LumpedPortType=Modal Modes{Mode1{IntLine{(-82.75, 52.5, 0) -> (-82.25, 52.5, 0)} CharImp=Zpi}} Impedance=50ohm
  P044: Lumped Port Objects=PortSheet_044 LumpedPortType=Modal Modes{Mode1{IntLine{(-82.75, 67.5, 0) -> (-82.25, 67.5, 0)} CharImp=Zpi}} Impedance=50ohm
  P045: Lumped Port Objects=PortSheet_045 LumpedPortType=Modal Modes{Mode1{IntLine{(-82.75, 82.5, 0) -> (-82.25, 82.5, 0)} CharImp=Zpi}} Impedance=50ohm
  P046: Lumped Port Objects=PortSheet_046 LumpedPortType=Modal Modes{Mode1{IntLine{(-82.75, 97.5, 0) -> (-82.25, 97.5, 0)} CharImp=Zpi}} Impedance=50ohm
  P047: Lumped Port Objects=PortSheet_047 LumpedPortType=Modal Modes{Mode1{IntLine{(-82.75, 112.5, 0) -> (-82.25, 112.5, 0)} CharImp=Zpi}} Impedance=50ohm
  P048: Lumped Port Objects=PortSheet_048 LumpedPortType=Modal Modes{Mode1{IntLine{(-67.75, -112.5, 0) -> (-67.25, -112.5, 0)} CharImp=Zpi}} Impedance=50ohm
  P049: Lumped Port Objects=PortSheet_049 LumpedPortType=Modal Modes{Mode1{IntLine{(-67.75, -97.5, 0) -> (-67.25, -97.5, 0)} CharImp=Zpi}} Impedance=50ohm
  P050: Lumped Port Objects=PortSheet_050 LumpedPortType=Modal Modes{Mode1{IntLine{(-67.75, -82.5, 0) -> (-67.25, -82.5, 0)} CharImp=Zpi}} Impedance=50ohm
  P051: Lumped Port Objects=PortSheet_051 LumpedPortType=Modal Modes{Mode1{IntLine{(-67.75, -67.5, 0) -> (-67.25, -67.5, 0)} CharImp=Zpi}} Impedance=50ohm
  P052: Lumped Port Objects=PortSheet_052 LumpedPortType=Modal Modes{Mode1{IntLine{(-67.75, -52.5, 0) -> (-67.25, -52.5, 0)} CharImp=Zpi}} Impedance=50ohm
  P053: Lumped Port Objects=PortSheet_053 LumpedPortType=Modal Modes{Mode1{IntLine{(-67.75, -37.5, 0) -> (-67.25, -37.5, 0)} CharImp=Zpi}} Impedance=50ohm
  P054: Lumped Port Objects=PortSheet_054 LumpedPortType=Modal Modes{Mode1{IntLine{(-67.75, -22.5, 0) -> (-67.25, -22.5, 0)} CharImp=Zpi}} Impedance=50ohm
  P055: Lumped Port Objects=PortSheet_055 LumpedPortType=Modal Modes{Mode1{IntLine{(-67.75, -7.5, 0) -> (-67.25, -7.5, 0)} CharImp=Zpi}} Impedance=50ohm
  P056: Lumped Port Objects=PortSheet_056 LumpedPortType=Modal Modes{Mode1{IntLine{(-67.75, 7.5, 0) -> (-67.25, 7.5, 0)} CharImp=Zpi}} Impedance=50ohm
  P057: Lumped Port Objects=PortSheet_057 LumpedPortType=Modal Modes{Mode1{IntLine{(-67.75, 22.5, 0) -> (-67.25, 22.5, 0)} CharImp=Zpi}} Impedance=50ohm
  P058: Lumped Port Objects=PortSheet_058 LumpedPortType=Modal Modes{Mode1{IntLine{(-67.75, 37.5, 0) -> (-67.25, 37.5, 0)} CharImp=Zpi}} Impedance=50ohm
  P059: Lumped Port Objects=PortSheet_059 LumpedPortType=Modal Modes{Mode1{IntLine{(-67.75, 52.5, 0) -> (-67.25, 52.5, 0)} CharImp=Zpi}} Impedance=50ohm
  P060: Lumped Port Objects=PortSheet_060 LumpedPortType=Modal Modes{Mode1{IntLine{(-67.75, 67.5, 0) -> (-67.25, 67.5, 0)} CharImp=Zpi}} Impedance=50ohm
  P061: Lumped Port Objects=PortSheet_061 LumpedPortType=Modal Modes{Mode1{IntLine{(-67.75, 82.5, 0) -> (-67.25, 82.5, 0)} CharImp=Zpi}} Impedance=50ohm
  P062: Lumped Port Objects=PortSheet_062 LumpedPortType=Modal Modes{Mode1{IntLine{(-67.75, 97.5, 0) -> (-67.25, 97.5, 0)} CharImp=Zpi}} Impedance=50ohm
  P063: Lumped Port Objects=PortSheet_063 LumpedPortType=Modal Modes{Mode1{IntLine{(-67.75, 112.5, 0) -> (-67.25, 112.5, 0)} CharImp=Zpi}} Impedance=50ohm
  P064: Lumped Port Objects=PortSheet_064 LumpedPortType=Modal Modes{Mode1{IntLine{(-52.75, -112.5, 0) -> (-52.25, -112.5, 0)} CharImp=Zpi}} Impedance=50ohm
  P065: Lumped Port Objects=PortSheet_065 LumpedPortType=Modal Modes{Mode1{IntLine{(-52.75, -97.5, 0) -> (-52.25, -97.5, 0)} CharImp=Zpi}} Impedance=50ohm
  P066: Lumped Port Objects=PortSheet_066 LumpedPortType=Modal Modes{Mode1{IntLine{(-52.75, -82.5, 0) -> (-52.25, -82.5, 0)} CharImp=Zpi}} Impedance=50ohm
  P067: Lumped Port Objects=PortSheet_067 LumpedPortType=Modal Modes{Mode1{IntLine{(-52.75, -67.5, 0) -> (-52.25, -67.5, 0)} CharImp=Zpi}} Impedance=50ohm
  P068: Lumped Port Objects=PortSheet_068 LumpedPortType=Modal Modes{Mode1{IntLine{(-52.75, -52.5, 0) -> (-52.25, -52.5, 0)} CharImp=Zpi}} Impedance=50ohm
  P069: Lumped Port Objects=PortSheet_069 LumpedPortType=Modal Modes{Mode1{IntLine{(-52.75, -37.5, 0) -> (-52.25, -37.5, 0)} CharImp=Zpi}} Impedance=50ohm
  P070: Lumped Port Objects=PortSheet_070 LumpedPortType=Modal Modes{Mode1{IntLine{(-52.75, -22.5, 0) -> (-52.25, -22.5, 0)} CharImp=Zpi}} Impedance=50ohm
  P071: Lumped Port Objects=PortSheet_071 LumpedPortType=Modal Modes{Mode1{IntLine{(-52.75, -7.5, 0) -> (-52.25, -7.5, 0)} CharImp=Zpi}} Impedance=50ohm
  P072: Lumped Port Objects=PortSheet_072 LumpedPortType=Modal Modes{Mode1{IntLine{(-52.75, 7.5, 0) -> (-52.25, 7.5, 0)} CharImp=Zpi}} Impedance=50ohm
  P073: Lumped Port Objects=PortSheet_073 LumpedPortType=Modal Modes{Mode1{IntLine{(-52.75, 22.5, 0) -> (-52.25, 22.5, 0)} CharImp=Zpi}} Impedance=50ohm
  P074: Lumped Port Objects=PortSheet_074 LumpedPortType=Modal Modes{Mode1{IntLine{(-52.75, 37.5, 0) -> (-52.25, 37.5, 0)} CharImp=Zpi}} Impedance=50ohm
  P075: Lumped Port Objects=PortSheet_075 LumpedPortType=Modal Modes{Mode1{IntLine{(-52.75, 52.5, 0) -> (-52.25, 52.5, 0)} CharImp=Zpi}} Impedance=50ohm
  P076: Lumped Port Objects=PortSheet_076 LumpedPortType=Modal Modes{Mode1{IntLine{(-52.75, 67.5, 0) -> (-52.25, 67.5, 0)} CharImp=Zpi}} Impedance=50ohm
  P077: Lumped Port Objects=PortSheet_077 LumpedPortType=Modal Modes{Mode1{IntLine{(-52.75, 82.5, 0) -> (-52.25, 82.5, 0)} CharImp=Zpi}} Impedance=50ohm
  P078: Lumped Port Objects=PortSheet_078 LumpedPortType=Modal Modes{Mode1{IntLine{(-52.75, 97.5, 0) -> (-52.25, 97.5, 0)} CharImp=Zpi}} Impedance=50ohm
  P079: Lumped Port Objects=PortSheet_079 LumpedPortType=Modal Modes{Mode1{IntLine{(-52.75, 112.5, 0) -> (-52.25, 112.5, 0)} CharImp=Zpi}} Impedance=50ohm
  P080: Lumped Port Objects=PortSheet_080 LumpedPortType=Modal Modes{Mode1{IntLine{(-37.75, -112.5, 0) -> (-37.25, -112.5, 0)} CharImp=Zpi}} Impedance=50ohm
  P081: Lumped Port Objects=PortSheet_081 LumpedPortType=Modal Modes{Mode1{IntLine{(-37.75, -97.5, 0) -> (-37.25, -97.5, 0)} CharImp=Zpi}} Impedance=50ohm
  P082: Lumped Port Objects=PortSheet_082 LumpedPortType=Modal Modes{Mode1{IntLine{(-37.75, -82.5, 0) -> (-37.25, -82.5, 0)} CharImp=Zpi}} Impedance=50ohm
  P083: Lumped Port Objects=PortSheet_083 LumpedPortType=Modal Modes{Mode1{IntLine{(-37.75, -67.5, 0) -> (-37.25, -67.5, 0)} CharImp=Zpi}} Impedance=50ohm
  P084: Lumped Port Objects=PortSheet_084 LumpedPortType=Modal Modes{Mode1{IntLine{(-37.75, -52.5, 0) -> (-37.25, -52.5, 0)} CharImp=Zpi}} Impedance=50ohm
  P085: Lumped Port Objects=PortSheet_085 LumpedPortType=Modal Modes{Mode1{IntLine{(-37.75, -37.5, 0) -> (-37.25, -37.5, 0)} CharImp=Zpi}} Impedance=50ohm
  P086: Lumped Port Objects=PortSheet_086 LumpedPortType=Modal Modes{Mode1{IntLine{(-37.75, -22.5, 0) -> (-37.25, -22.5, 0)} CharImp=Zpi}} Impedance=50ohm
  P087: Lumped Port Objects=PortSheet_087 LumpedPortType=Modal Modes{Mode1{IntLine{(-37.75, -7.5, 0) -> (-37.25, -7.5, 0)} CharImp=Zpi}} Impedance=50ohm
  P088: Lumped Port Objects=PortSheet_088 LumpedPortType=Modal Modes{Mode1{IntLine{(-37.75, 7.5, 0) -> (-37.25, 7.5, 0)} CharImp=Zpi}} Impedance=50ohm
  P089: Lumped Port Objects=PortSheet_089 LumpedPortType=Modal Modes{Mode1{IntLine{(-37.75, 22.5, 0) -> (-37.25, 22.5, 0)} CharImp=Zpi}} Impedance=50ohm
  P090: Lumped Port Objects=PortSheet_090 LumpedPortType=Modal Modes{Mode1{IntLine{(-37.75, 37.5, 0) -> (-37.25, 37.5, 0)} CharImp=Zpi}} Impedance=50ohm
  P091: Lumped Port Objects=PortSheet_091 LumpedPortType=Modal Modes{Mode1{IntLine{(-37.75, 52.5, 0) -> (-37.25, 52.5, 0)} CharImp=Zpi}} Impedance=50ohm
  P092: Lumped Port Objects=PortSheet_092 LumpedPortType=Modal Modes{Mode1{IntLine{(-37.75, 67.5, 0) -> (-37.25, 67.5, 0)} CharImp=Zpi}} Impedance=50ohm
  P093: Lumped Port Objects=PortSheet_093 LumpedPortType=Modal Modes{Mode1{IntLine{(-37.75, 82.5, 0) -> (-37.25, 82.5, 0)} CharImp=Zpi}} Impedance=50ohm
  P094: Lumped Port Objects=PortSheet_094 LumpedPortType=Modal Modes{Mode1{IntLine{(-37.75, 97.5, 0) -> (-37.25, 97.5, 0)} CharImp=Zpi}} Impedance=50ohm
  P095: Lumped Port Objects=PortSheet_095 LumpedPortType=Modal Modes{Mode1{IntLine{(-37.75, 112.5, 0) -> (-37.25, 112.5, 0)} CharImp=Zpi}} Impedance=50ohm
  P096: Lumped Port Objects=PortSheet_096 LumpedPortType=Modal Modes{Mode1{IntLine{(-22.75, -112.5, 0) -> (-22.25, -112.5, 0)} CharImp=Zpi}} Impedance=50ohm
  P097: Lumped Port Objects=PortSheet_097 LumpedPortType=Modal Modes{Mode1{IntLine{(-22.75, -97.5, 0) -> (-22.25, -97.5, 0)} CharImp=Zpi}} Impedance=50ohm
  P098: Lumped Port Objects=PortSheet_098 LumpedPortType=Modal Modes{Mode1{IntLine{(-22.75, -82.5, 0) -> (-22.25, -82.5, 0)} CharImp=Zpi}} Impedance=50ohm
  P099: Lumped Port Objects=PortSheet_099 LumpedPortType=Modal Modes{Mode1{IntLine{(-22.75, -67.5, 0) -> (-22.25, -67.5, 0)} CharImp=Zpi}} Impedance=50ohm
  P100: Lumped Port Objects=PortSheet_100 LumpedPortType=Modal Modes{Mode1{IntLine{(-22.75, -52.5, 0) -> (-22.25, -52.5, 0)} CharImp=Zpi}} Impedance=50ohm
  P101: Lumped Port Objects=PortSheet_101 LumpedPortType=Modal Modes{Mode1{IntLine{(-22.75, -37.5, 0) -> (-22.25, -37.5, 0)} CharImp=Zpi}} Impedance=50ohm
  P102: Lumped Port Objects=PortSheet_102 LumpedPortType=Modal Modes{Mode1{IntLine{(-22.75, -22.5, 0) -> (-22.25, -22.5, 0)} CharImp=Zpi}} Impedance=50ohm
  P103: Lumped Port Objects=PortSheet_103 LumpedPortType=Modal Modes{Mode1{IntLine{(-22.75, -7.5, 0) -> (-22.25, -7.5, 0)} CharImp=Zpi}} Impedance=50ohm
  P104: Lumped Port Objects=PortSheet_104 LumpedPortType=Modal Modes{Mode1{IntLine{(-22.75, 7.5, 0) -> (-22.25, 7.5, 0)} CharImp=Zpi}} Impedance=50ohm
  P105: Lumped Port Objects=PortSheet_105 LumpedPortType=Modal Modes{Mode1{IntLine{(-22.75, 22.5, 0) -> (-22.25, 22.5, 0)} CharImp=Zpi}} Impedance=50ohm
  P106: Lumped Port Objects=PortSheet_106 LumpedPortType=Modal Modes{Mode1{IntLine{(-22.75, 37.5, 0) -> (-22.25, 37.5, 0)} CharImp=Zpi}} Impedance=50ohm
  P107: Lumped Port Objects=PortSheet_107 LumpedPortType=Modal Modes{Mode1{IntLine{(-22.75, 52.5, 0) -> (-22.25, 52.5, 0)} CharImp=Zpi}} Impedance=50ohm
  P108: Lumped Port Objects=PortSheet_108 LumpedPortType=Modal Modes{Mode1{IntLine{(-22.75, 67.5, 0) -> (-22.25, 67.5, 0)} CharImp=Zpi}} Impedance=50ohm
  P109: Lumped Port Objects=PortSheet_109 LumpedPortType=Modal Modes{Mode1{IntLine{(-22.75, 82.5, 0) -> (-22.25, 82.5, 0)} CharImp=Zpi}} Impedance=50ohm
  P110: Lumped Port Objects=PortSheet_110 LumpedPortType=Modal Modes{Mode1{IntLine{(-22.75, 97.5, 0) -> (-22.25, 97.5, 0)} CharImp=Zpi}} Impedance=50ohm
  P111: Lumped Port Objects=PortSheet_111 LumpedPortType=Modal Modes{Mode1{IntLine{(-22.75, 112.5, 0) -> (-22.25, 112.5, 0)} CharImp=Zpi}} Impedance=50ohm
  P112: Lumped Port Objects=PortSheet_112 LumpedPortType=Modal Modes{Mode1{IntLine{(-7.75, -112.5, 0) -> (-7.25, -112.5, 0)} CharImp=Zpi}} Impedance=50ohm
  P113: Lumped Port Objects=PortSheet_113 LumpedPortType=Modal Modes{Mode1{IntLine{(-7.75, -97.5, 0) -> (-7.25, -97.5, 0)} CharImp=Zpi}} Impedance=50ohm
  P114: Lumped Port Objects=PortSheet_114 LumpedPortType=Modal Modes{Mode1{IntLine{(-7.75, -82.5, 0) -> (-7.25, -82.5, 0)} CharImp=Zpi}} Impedance=50ohm
  P115: Lumped Port Objects=PortSheet_115 LumpedPortType=Modal Modes{Mode1{IntLine{(-7.75, -67.5, 0) -> (-7.25, -67.5, 0)} CharImp=Zpi}} Impedance=50ohm
  P116: Lumped Port Objects=PortSheet_116 LumpedPortType=Modal Modes{Mode1{IntLine{(-7.75, -52.5, 0) -> (-7.25, -52.5, 0)} CharImp=Zpi}} Impedance=50ohm
  P117: Lumped Port Objects=PortSheet_117 LumpedPortType=Modal Modes{Mode1{IntLine{(-7.75, -37.5, 0) -> (-7.25, -37.5, 0)} CharImp=Zpi}} Impedance=50ohm
  P118: Lumped Port Objects=PortSheet_118 LumpedPortType=Modal Modes{Mode1{IntLine{(-7.75, -22.5, 0) -> (-7.25, -22.5, 0)} CharImp=Zpi}} Impedance=50ohm
  P119: Lumped Port Objects=PortSheet_119 LumpedPortType=Modal Modes{Mode1{IntLine{(-7.75, -7.5, 0) -> (-7.25, -7.5, 0)} CharImp=Zpi}} Impedance=50ohm
  P120: Lumped Port Objects=PortSheet_120 LumpedPortType=Modal Modes{Mode1{IntLine{(-7.75, 7.5, 0) -> (-7.25, 7.5, 0)} CharImp=Zpi}} Impedance=50ohm
  P121: Lumped Port Objects=PortSheet_121 LumpedPortType=Modal Modes{Mode1{IntLine{(-7.75, 22.5, 0) -> (-7.25, 22.5, 0)} CharImp=Zpi}} Impedance=50ohm
  P122: Lumped Port Objects=PortSheet_122 LumpedPortType=Modal Modes{Mode1{IntLine{(-7.75, 37.5, 0) -> (-7.25, 37.5, 0)} CharImp=Zpi}} Impedance=50ohm
  P123: Lumped Port Objects=PortSheet_123 LumpedPortType=Modal Modes{Mode1{IntLine{(-7.75, 52.5, 0) -> (-7.25, 52.5, 0)} CharImp=Zpi}} Impedance=50ohm
  P124: Lumped Port Objects=PortSheet_124 LumpedPortType=Modal Modes{Mode1{IntLine{(-7.75, 67.5, 0) -> (-7.25, 67.5, 0)} CharImp=Zpi}} Impedance=50ohm
  P125: Lumped Port Objects=PortSheet_125 LumpedPortType=Modal Modes{Mode1{IntLine{(-7.75, 82.5, 0) -> (-7.25, 82.5, 0)} CharImp=Zpi}} Impedance=50ohm
  P126: Lumped Port Objects=PortSheet_126 LumpedPortType=Modal Modes{Mode1{IntLine{(-7.75, 97.5, 0) -> (-7.25, 97.5, 0)} CharImp=Zpi}} Impedance=50ohm
  P127: Lumped Port Objects=PortSheet_127 LumpedPortType=Modal Modes{Mode1{IntLine{(-7.75, 112.5, 0) -> (-7.25, 112.5, 0)} CharImp=Zpi}} Impedance=50ohm
  P128: Lumped Port Objects=PortSheet_128 LumpedPortType=Modal Modes{Mode1{IntLine{(7.25, -112.5, 0) -> (7.75, -112.5, 0)} CharImp=Zpi}} Impedance=50ohm
  P129: Lumped Port Objects=PortSheet_129 LumpedPortType=Modal Modes{Mode1{IntLine{(7.25, -97.5, 0) -> (7.75, -97.5, 0)} CharImp=Zpi}} Impedance=50ohm
  P130: Lumped Port Objects=PortSheet_130 LumpedPortType=Modal Modes{Mode1{IntLine{(7.25, -82.5, 0) -> (7.75, -82.5, 0)} CharImp=Zpi}} Impedance=50ohm
  P131: Lumped Port Objects=PortSheet_131 LumpedPortType=Modal Modes{Mode1{IntLine{(7.25, -67.5, 0) -> (7.75, -67.5, 0)} CharImp=Zpi}} Impedance=50ohm
  P132: Lumped Port Objects=PortSheet_132 LumpedPortType=Modal Modes{Mode1{IntLine{(7.25, -52.5, 0) -> (7.75, -52.5, 0)} CharImp=Zpi}} Impedance=50ohm
  P133: Lumped Port Objects=PortSheet_133 LumpedPortType=Modal Modes{Mode1{IntLine{(7.25, -37.5, 0) -> (7.75, -37.5, 0)} CharImp=Zpi}} Impedance=50ohm
  P134: Lumped Port Objects=PortSheet_134 LumpedPortType=Modal Modes{Mode1{IntLine{(7.25, -22.5, 0) -> (7.75, -22.5, 0)} CharImp=Zpi}} Impedance=50ohm
  P135: Lumped Port Objects=PortSheet_135 LumpedPortType=Modal Modes{Mode1{IntLine{(7.25, -7.5, 0) -> (7.75, -7.5, 0)} CharImp=Zpi}} Impedance=50ohm
  P136: Lumped Port Objects=PortSheet_136 LumpedPortType=Modal Modes{Mode1{IntLine{(7.25, 7.5, 0) -> (7.75, 7.5, 0)} CharImp=Zpi}} Impedance=50ohm
  P137: Lumped Port Objects=PortSheet_137 LumpedPortType=Modal Modes{Mode1{IntLine{(7.25, 22.5, 0) -> (7.75, 22.5, 0)} CharImp=Zpi}} Impedance=50ohm
  P138: Lumped Port Objects=PortSheet_138 LumpedPortType=Modal Modes{Mode1{IntLine{(7.25, 37.5, 0) -> (7.75, 37.5, 0)} CharImp=Zpi}} Impedance=50ohm
  P139: Lumped Port Objects=PortSheet_139 LumpedPortType=Modal Modes{Mode1{IntLine{(7.25, 52.5, 0) -> (7.75, 52.5, 0)} CharImp=Zpi}} Impedance=50ohm
  P140: Lumped Port Objects=PortSheet_140 LumpedPortType=Modal Modes{Mode1{IntLine{(7.25, 67.5, 0) -> (7.75, 67.5, 0)} CharImp=Zpi}} Impedance=50ohm
  P141: Lumped Port Objects=PortSheet_141 LumpedPortType=Modal Modes{Mode1{IntLine{(7.25, 82.5, 0) -> (7.75, 82.5, 0)} CharImp=Zpi}} Impedance=50ohm
  P142: Lumped Port Objects=PortSheet_142 LumpedPortType=Modal Modes{Mode1{IntLine{(7.25, 97.5, 0) -> (7.75, 97.5, 0)} CharImp=Zpi}} Impedance=50ohm
  P143: Lumped Port Objects=PortSheet_143 LumpedPortType=Modal Modes{Mode1{IntLine{(7.25, 112.5, 0) -> (7.75, 112.5, 0)} CharImp=Zpi}} Impedance=50ohm
  P144: Lumped Port Objects=PortSheet_144 LumpedPortType=Modal Modes{Mode1{IntLine{(22.25, -112.5, 0) -> (22.75, -112.5, 0)} CharImp=Zpi}} Impedance=50ohm
  P145: Lumped Port Objects=PortSheet_145 LumpedPortType=Modal Modes{Mode1{IntLine{(22.25, -97.5, 0) -> (22.75, -97.5, 0)} CharImp=Zpi}} Impedance=50ohm
  P146: Lumped Port Objects=PortSheet_146 LumpedPortType=Modal Modes{Mode1{IntLine{(22.25, -82.5, 0) -> (22.75, -82.5, 0)} CharImp=Zpi}} Impedance=50ohm
  P147: Lumped Port Objects=PortSheet_147 LumpedPortType=Modal Modes{Mode1{IntLine{(22.25, -67.5, 0) -> (22.75, -67.5, 0)} CharImp=Zpi}} Impedance=50ohm
  P148: Lumped Port Objects=PortSheet_148 LumpedPortType=Modal Modes{Mode1{IntLine{(22.25, -52.5, 0) -> (22.75, -52.5, 0)} CharImp=Zpi}} Impedance=50ohm
  P149: Lumped Port Objects=PortSheet_149 LumpedPortType=Modal Modes{Mode1{IntLine{(22.25, -37.5, 0) -> (22.75, -37.5, 0)} CharImp=Zpi}} Impedance=50ohm
  P150: Lumped Port Objects=PortSheet_150 LumpedPortType=Modal Modes{Mode1{IntLine{(22.25, -22.5, 0) -> (22.75, -22.5, 0)} CharImp=Zpi}} Impedance=50ohm
  P151: Lumped Port Objects=PortSheet_151 LumpedPortType=Modal Modes{Mode1{IntLine{(22.25, -7.5, 0) -> (22.75, -7.5, 0)} CharImp=Zpi}} Impedance=50ohm
  P152: Lumped Port Objects=PortSheet_152 LumpedPortType=Modal Modes{Mode1{IntLine{(22.25, 7.5, 0) -> (22.75, 7.5, 0)} CharImp=Zpi}} Impedance=50ohm
  P153: Lumped Port Objects=PortSheet_153 LumpedPortType=Modal Modes{Mode1{IntLine{(22.25, 22.5, 0) -> (22.75, 22.5, 0)} CharImp=Zpi}} Impedance=50ohm
  P154: Lumped Port Objects=PortSheet_154 LumpedPortType=Modal Modes{Mode1{IntLine{(22.25, 37.5, 0) -> (22.75, 37.5, 0)} CharImp=Zpi}} Impedance=50ohm
  P155: Lumped Port Objects=PortSheet_155 LumpedPortType=Modal Modes{Mode1{IntLine{(22.25, 52.5, 0) -> (22.75, 52.5, 0)} CharImp=Zpi}} Impedance=50ohm
  P156: Lumped Port Objects=PortSheet_156 LumpedPortType=Modal Modes{Mode1{IntLine{(22.25, 67.5, 0) -> (22.75, 67.5, 0)} CharImp=Zpi}} Impedance=50ohm
  P157: Lumped Port Objects=PortSheet_157 LumpedPortType=Modal Modes{Mode1{IntLine{(22.25, 82.5, 0) -> (22.75, 82.5, 0)} CharImp=Zpi}} Impedance=50ohm
  P158: Lumped Port Objects=PortSheet_158 LumpedPortType=Modal Modes{Mode1{IntLine{(22.25, 97.5, 0) -> (22.75, 97.5, 0)} CharImp=Zpi}} Impedance=50ohm
  P159: Lumped Port Objects=PortSheet_159 LumpedPortType=Modal Modes{Mode1{IntLine{(22.25, 112.5, 0) -> (22.75, 112.5, 0)} CharImp=Zpi}} Impedance=50ohm
  P160: Lumped Port Objects=PortSheet_160 LumpedPortType=Modal Modes{Mode1{IntLine{(37.25, -112.5, 0) -> (37.75, -112.5, 0)} CharImp=Zpi}} Impedance=50ohm
  P161: Lumped Port Objects=PortSheet_161 LumpedPortType=Modal Modes{Mode1{IntLine{(37.25, -97.5, 0) -> (37.75, -97.5, 0)} CharImp=Zpi}} Impedance=50ohm
  P162: Lumped Port Objects=PortSheet_162 LumpedPortType=Modal Modes{Mode1{IntLine{(37.25, -82.5, 0) -> (37.75, -82.5, 0)} CharImp=Zpi}} Impedance=50ohm
  P163: Lumped Port Objects=PortSheet_163 LumpedPortType=Modal Modes{Mode1{IntLine{(37.25, -67.5, 0) -> (37.75, -67.5, 0)} CharImp=Zpi}} Impedance=50ohm
  P164: Lumped Port Objects=PortSheet_164 LumpedPortType=Modal Modes{Mode1{IntLine{(37.25, -52.5, 0) -> (37.75, -52.5, 0)} CharImp=Zpi}} Impedance=50ohm
  P165: Lumped Port Objects=PortSheet_165 LumpedPortType=Modal Modes{Mode1{IntLine{(37.25, -37.5, 0) -> (37.75, -37.5, 0)} CharImp=Zpi}} Impedance=50ohm
  P166: Lumped Port Objects=PortSheet_166 LumpedPortType=Modal Modes{Mode1{IntLine{(37.25, -22.5, 0) -> (37.75, -22.5, 0)} CharImp=Zpi}} Impedance=50ohm
  P167: Lumped Port Objects=PortSheet_167 LumpedPortType=Modal Modes{Mode1{IntLine{(37.25, -7.5, 0) -> (37.75, -7.5, 0)} CharImp=Zpi}} Impedance=50ohm
  P168: Lumped Port Objects=PortSheet_168 LumpedPortType=Modal Modes{Mode1{IntLine{(37.25, 7.5, 0) -> (37.75, 7.5, 0)} CharImp=Zpi}} Impedance=50ohm
  P169: Lumped Port Objects=PortSheet_169 LumpedPortType=Modal Modes{Mode1{IntLine{(37.25, 22.5, 0) -> (37.75, 22.5, 0)} CharImp=Zpi}} Impedance=50ohm
  P170: Lumped Port Objects=PortSheet_170 LumpedPortType=Modal Modes{Mode1{IntLine{(37.25, 37.5, 0) -> (37.75, 37.5, 0)} CharImp=Zpi}} Impedance=50ohm
  P171: Lumped Port Objects=PortSheet_171 LumpedPortType=Modal Modes{Mode1{IntLine{(37.25, 52.5, 0) -> (37.75, 52.5, 0)} CharImp=Zpi}} Impedance=50ohm
  P172: Lumped Port Objects=PortSheet_172 LumpedPortType=Modal Modes{Mode1{IntLine{(37.25, 67.5, 0) -> (37.75, 67.5, 0)} CharImp=Zpi}} Impedance=50ohm
  P173: Lumped Port Objects=PortSheet_173 LumpedPortType=Modal Modes{Mode1{IntLine{(37.25, 82.5, 0) -> (37.75, 82.5, 0)} CharImp=Zpi}} Impedance=50ohm
  P174: Lumped Port Objects=PortSheet_174 LumpedPortType=Modal Modes{Mode1{IntLine{(37.25, 97.5, 0) -> (37.75, 97.5, 0)} CharImp=Zpi}} Impedance=50ohm
  P175: Lumped Port Objects=PortSheet_175 LumpedPortType=Modal Modes{Mode1{IntLine{(37.25, 112.5, 0) -> (37.75, 112.5, 0)} CharImp=Zpi}} Impedance=50ohm
  P176: Lumped Port Objects=PortSheet_176 LumpedPortType=Modal Modes{Mode1{IntLine{(52.25, -112.5, 0) -> (52.75, -112.5, 0)} CharImp=Zpi}} Impedance=50ohm
  P177: Lumped Port Objects=PortSheet_177 LumpedPortType=Modal Modes{Mode1{IntLine{(52.25, -97.5, 0) -> (52.75, -97.5, 0)} CharImp=Zpi}} Impedance=50ohm
  P178: Lumped Port Objects=PortSheet_178 LumpedPortType=Modal Modes{Mode1{IntLine{(52.25, -82.5, 0) -> (52.75, -82.5, 0)} CharImp=Zpi}} Impedance=50ohm
  P179: Lumped Port Objects=PortSheet_179 LumpedPortType=Modal Modes{Mode1{IntLine{(52.25, -67.5, 0) -> (52.75, -67.5, 0)} CharImp=Zpi}} Impedance=50ohm
  P180: Lumped Port Objects=PortSheet_180 LumpedPortType=Modal Modes{Mode1{IntLine{(52.25, -52.5, 0) -> (52.75, -52.5, 0)} CharImp=Zpi}} Impedance=50ohm
  P181: Lumped Port Objects=PortSheet_181 LumpedPortType=Modal Modes{Mode1{IntLine{(52.25, -37.5, 0) -> (52.75, -37.5, 0)} CharImp=Zpi}} Impedance=50ohm
  P182: Lumped Port Objects=PortSheet_182 LumpedPortType=Modal Modes{Mode1{IntLine{(52.25, -22.5, 0) -> (52.75, -22.5, 0)} CharImp=Zpi}} Impedance=50ohm
  P183: Lumped Port Objects=PortSheet_183 LumpedPortType=Modal Modes{Mode1{IntLine{(52.25, -7.5, 0) -> (52.75, -7.5, 0)} CharImp=Zpi}} Impedance=50ohm
  P184: Lumped Port Objects=PortSheet_184 LumpedPortType=Modal Modes{Mode1{IntLine{(52.25, 7.5, 0) -> (52.75, 7.5, 0)} CharImp=Zpi}} Impedance=50ohm
  P185: Lumped Port Objects=PortSheet_185 LumpedPortType=Modal Modes{Mode1{IntLine{(52.25, 22.5, 0) -> (52.75, 22.5, 0)} CharImp=Zpi}} Impedance=50ohm
  P186: Lumped Port Objects=PortSheet_186 LumpedPortType=Modal Modes{Mode1{IntLine{(52.25, 37.5, 0) -> (52.75, 37.5, 0)} CharImp=Zpi}} Impedance=50ohm
  P187: Lumped Port Objects=PortSheet_187 LumpedPortType=Modal Modes{Mode1{IntLine{(52.25, 52.5, 0) -> (52.75, 52.5, 0)} CharImp=Zpi}} Impedance=50ohm
  P188: Lumped Port Objects=PortSheet_188 LumpedPortType=Modal Modes{Mode1{IntLine{(52.25, 67.5, 0) -> (52.75, 67.5, 0)} CharImp=Zpi}} Impedance=50ohm
  P189: Lumped Port Objects=PortSheet_189 LumpedPortType=Modal Modes{Mode1{IntLine{(52.25, 82.5, 0) -> (52.75, 82.5, 0)} CharImp=Zpi}} Impedance=50ohm
  P190: Lumped Port Objects=PortSheet_190 LumpedPortType=Modal Modes{Mode1{IntLine{(52.25, 97.5, 0) -> (52.75, 97.5, 0)} CharImp=Zpi}} Impedance=50ohm
  P191: Lumped Port Objects=PortSheet_191 LumpedPortType=Modal Modes{Mode1{IntLine{(52.25, 112.5, 0) -> (52.75, 112.5, 0)} CharImp=Zpi}} Impedance=50ohm
  P192: Lumped Port Objects=PortSheet_192 LumpedPortType=Modal Modes{Mode1{IntLine{(67.25, -112.5, 0) -> (67.75, -112.5, 0)} CharImp=Zpi}} Impedance=50ohm
  P193: Lumped Port Objects=PortSheet_193 LumpedPortType=Modal Modes{Mode1{IntLine{(67.25, -97.5, 0) -> (67.75, -97.5, 0)} CharImp=Zpi}} Impedance=50ohm
  P194: Lumped Port Objects=PortSheet_194 LumpedPortType=Modal Modes{Mode1{IntLine{(67.25, -82.5, 0) -> (67.75, -82.5, 0)} CharImp=Zpi}} Impedance=50ohm
  P195: Lumped Port Objects=PortSheet_195 LumpedPortType=Modal Modes{Mode1{IntLine{(67.25, -67.5, 0) -> (67.75, -67.5, 0)} CharImp=Zpi}} Impedance=50ohm
  P196: Lumped Port Objects=PortSheet_196 LumpedPortType=Modal Modes{Mode1{IntLine{(67.25, -52.5, 0) -> (67.75, -52.5, 0)} CharImp=Zpi}} Impedance=50ohm
  P197: Lumped Port Objects=PortSheet_197 LumpedPortType=Modal Modes{Mode1{IntLine{(67.25, -37.5, 0) -> (67.75, -37.5, 0)} CharImp=Zpi}} Impedance=50ohm
  P198: Lumped Port Objects=PortSheet_198 LumpedPortType=Modal Modes{Mode1{IntLine{(67.25, -22.5, 0) -> (67.75, -22.5, 0)} CharImp=Zpi}} Impedance=50ohm
  P199: Lumped Port Objects=PortSheet_199 LumpedPortType=Modal Modes{Mode1{IntLine{(67.25, -7.5, 0) -> (67.75, -7.5, 0)} CharImp=Zpi}} Impedance=50ohm
  P200: Lumped Port Objects=PortSheet_200 LumpedPortType=Modal Modes{Mode1{IntLine{(67.25, 7.5, 0) -> (67.75, 7.5, 0)} CharImp=Zpi}} Impedance=50ohm
  P201: Lumped Port Objects=PortSheet_201 LumpedPortType=Modal Modes{Mode1{IntLine{(67.25, 22.5, 0) -> (67.75, 22.5, 0)} CharImp=Zpi}} Impedance=50ohm
  P202: Lumped Port Objects=PortSheet_202 LumpedPortType=Modal Modes{Mode1{IntLine{(67.25, 37.5, 0) -> (67.75, 37.5, 0)} CharImp=Zpi}} Impedance=50ohm
  P203: Lumped Port Objects=PortSheet_203 LumpedPortType=Modal Modes{Mode1{IntLine{(67.25, 52.5, 0) -> (67.75, 52.5, 0)} CharImp=Zpi}} Impedance=50ohm
  P204: Lumped Port Objects=PortSheet_204 LumpedPortType=Modal Modes{Mode1{IntLine{(67.25, 67.5, 0) -> (67.75, 67.5, 0)} CharImp=Zpi}} Impedance=50ohm
  P205: Lumped Port Objects=PortSheet_205 LumpedPortType=Modal Modes{Mode1{IntLine{(67.25, 82.5, 0) -> (67.75, 82.5, 0)} CharImp=Zpi}} Impedance=50ohm
  P206: Lumped Port Objects=PortSheet_206 LumpedPortType=Modal Modes{Mode1{IntLine{(67.25, 97.5, 0) -> (67.75, 97.5, 0)} CharImp=Zpi}} Impedance=50ohm
  P207: Lumped Port Objects=PortSheet_207 LumpedPortType=Modal Modes{Mode1{IntLine{(67.25, 112.5, 0) -> (67.75, 112.5, 0)} CharImp=Zpi}} Impedance=50ohm
  P208: Lumped Port Objects=PortSheet_208 LumpedPortType=Modal Modes{Mode1{IntLine{(82.25, -112.5, 0) -> (82.75, -112.5, 0)} CharImp=Zpi}} Impedance=50ohm
  P209: Lumped Port Objects=PortSheet_209 LumpedPortType=Modal Modes{Mode1{IntLine{(82.25, -97.5, 0) -> (82.75, -97.5, 0)} CharImp=Zpi}} Impedance=50ohm
  P210: Lumped Port Objects=PortSheet_210 LumpedPortType=Modal Modes{Mode1{IntLine{(82.25, -82.5, 0) -> (82.75, -82.5, 0)} CharImp=Zpi}} Impedance=50ohm
  P211: Lumped Port Objects=PortSheet_211 LumpedPortType=Modal Modes{Mode1{IntLine{(82.25, -67.5, 0) -> (82.75, -67.5, 0)} CharImp=Zpi}} Impedance=50ohm
  P212: Lumped Port Objects=PortSheet_212 LumpedPortType=Modal Modes{Mode1{IntLine{(82.25, -52.5, 0) -> (82.75, -52.5, 0)} CharImp=Zpi}} Impedance=50ohm
  P213: Lumped Port Objects=PortSheet_213 LumpedPortType=Modal Modes{Mode1{IntLine{(82.25, -37.5, 0) -> (82.75, -37.5, 0)} CharImp=Zpi}} Impedance=50ohm
  P214: Lumped Port Objects=PortSheet_214 LumpedPortType=Modal Modes{Mode1{IntLine{(82.25, -22.5, 0) -> (82.75, -22.5, 0)} CharImp=Zpi}} Impedance=50ohm
  P215: Lumped Port Objects=PortSheet_215 LumpedPortType=Modal Modes{Mode1{IntLine{(82.25, -7.5, 0) -> (82.75, -7.5, 0)} CharImp=Zpi}} Impedance=50ohm
  P216: Lumped Port Objects=PortSheet_216 LumpedPortType=Modal Modes{Mode1{IntLine{(82.25, 7.5, 0) -> (82.75, 7.5, 0)} CharImp=Zpi}} Impedance=50ohm
  P217: Lumped Port Objects=PortSheet_217 LumpedPortType=Modal Modes{Mode1{IntLine{(82.25, 22.5, 0) -> (82.75, 22.5, 0)} CharImp=Zpi}} Impedance=50ohm
  P218: Lumped Port Objects=PortSheet_218 LumpedPortType=Modal Modes{Mode1{IntLine{(82.25, 37.5, 0) -> (82.75, 37.5, 0)} CharImp=Zpi}} Impedance=50ohm
  P219: Lumped Port Objects=PortSheet_219 LumpedPortType=Modal Modes{Mode1{IntLine{(82.25, 52.5, 0) -> (82.75, 52.5, 0)} CharImp=Zpi}} Impedance=50ohm
  P220: Lumped Port Objects=PortSheet_220 LumpedPortType=Modal Modes{Mode1{IntLine{(82.25, 67.5, 0) -> (82.75, 67.5, 0)} CharImp=Zpi}} Impedance=50ohm
  P221: Lumped Port Objects=PortSheet_221 LumpedPortType=Modal Modes{Mode1{IntLine{(82.25, 82.5, 0) -> (82.75, 82.5, 0)} CharImp=Zpi}} Impedance=50ohm
  P222: Lumped Port Objects=PortSheet_222 LumpedPortType=Modal Modes{Mode1{IntLine{(82.25, 97.5, 0) -> (82.75, 97.5, 0)} CharImp=Zpi}} Impedance=50ohm
  P223: Lumped Port Objects=PortSheet_223 LumpedPortType=Modal Modes{Mode1{IntLine{(82.25, 112.5, 0) -> (82.75, 112.5, 0)} CharImp=Zpi}} Impedance=50ohm
  P224: Lumped Port Objects=PortSheet_224 LumpedPortType=Modal Modes{Mode1{IntLine{(97.25, -112.5, 0) -> (97.75, -112.5, 0)} CharImp=Zpi}} Impedance=50ohm
  P225: Lumped Port Objects=PortSheet_225 LumpedPortType=Modal Modes{Mode1{IntLine{(97.25, -97.5, 0) -> (97.75, -97.5, 0)} CharImp=Zpi}} Impedance=50ohm
  P226: Lumped Port Objects=PortSheet_226 LumpedPortType=Modal Modes{Mode1{IntLine{(97.25, -82.5, 0) -> (97.75, -82.5, 0)} CharImp=Zpi}} Impedance=50ohm
  P227: Lumped Port Objects=PortSheet_227 LumpedPortType=Modal Modes{Mode1{IntLine{(97.25, -67.5, 0) -> (97.75, -67.5, 0)} CharImp=Zpi}} Impedance=50ohm
  P228: Lumped Port Objects=PortSheet_228 LumpedPortType=Modal Modes{Mode1{IntLine{(97.25, -52.5, 0) -> (97.75, -52.5, 0)} CharImp=Zpi}} Impedance=50ohm
  P229: Lumped Port Objects=PortSheet_229 LumpedPortType=Modal Modes{Mode1{IntLine{(97.25, -37.5, 0) -> (97.75, -37.5, 0)} CharImp=Zpi}} Impedance=50ohm
  P230: Lumped Port Objects=PortSheet_230 LumpedPortType=Modal Modes{Mode1{IntLine{(97.25, -22.5, 0) -> (97.75, -22.5, 0)} CharImp=Zpi}} Impedance=50ohm
  P231: Lumped Port Objects=PortSheet_231 LumpedPortType=Modal Modes{Mode1{IntLine{(97.25, -7.5, 0) -> (97.75, -7.5, 0)} CharImp=Zpi}} Impedance=50ohm
  P232: Lumped Port Objects=PortSheet_232 LumpedPortType=Modal Modes{Mode1{IntLine{(97.25, 7.5, 0) -> (97.75, 7.5, 0)} CharImp=Zpi}} Impedance=50ohm
  P233: Lumped Port Objects=PortSheet_233 LumpedPortType=Modal Modes{Mode1{IntLine{(97.25, 22.5, 0) -> (97.75, 22.5, 0)} CharImp=Zpi}} Impedance=50ohm
  P234: Lumped Port Objects=PortSheet_234 LumpedPortType=Modal Modes{Mode1{IntLine{(97.25, 37.5, 0) -> (97.75, 37.5, 0)} CharImp=Zpi}} Impedance=50ohm
  P235: Lumped Port Objects=PortSheet_235 LumpedPortType=Modal Modes{Mode1{IntLine{(97.25, 52.5, 0) -> (97.75, 52.5, 0)} CharImp=Zpi}} Impedance=50ohm
  P236: Lumped Port Objects=PortSheet_236 LumpedPortType=Modal Modes{Mode1{IntLine{(97.25, 67.5, 0) -> (97.75, 67.5, 0)} CharImp=Zpi}} Impedance=50ohm
  P237: Lumped Port Objects=PortSheet_237 LumpedPortType=Modal Modes{Mode1{IntLine{(97.25, 82.5, 0) -> (97.75, 82.5, 0)} CharImp=Zpi}} Impedance=50ohm
  P238: Lumped Port Objects=PortSheet_238 LumpedPortType=Modal Modes{Mode1{IntLine{(97.25, 97.5, 0) -> (97.75, 97.5, 0)} CharImp=Zpi}} Impedance=50ohm
  P239: Lumped Port Objects=PortSheet_239 LumpedPortType=Modal Modes{Mode1{IntLine{(97.25, 112.5, 0) -> (97.75, 112.5, 0)} CharImp=Zpi}} Impedance=50ohm
  P240: Lumped Port Objects=PortSheet_240 LumpedPortType=Modal Modes{Mode1{IntLine{(112.25, -112.5, 0) -> (112.75, -112.5, 0)} CharImp=Zpi}} Impedance=50ohm
  P241: Lumped Port Objects=PortSheet_241 LumpedPortType=Modal Modes{Mode1{IntLine{(112.25, -97.5, 0) -> (112.75, -97.5, 0)} CharImp=Zpi}} Impedance=50ohm
  P242: Lumped Port Objects=PortSheet_242 LumpedPortType=Modal Modes{Mode1{IntLine{(112.25, -82.5, 0) -> (112.75, -82.5, 0)} CharImp=Zpi}} Impedance=50ohm
  P243: Lumped Port Objects=PortSheet_243 LumpedPortType=Modal Modes{Mode1{IntLine{(112.25, -67.5, 0) -> (112.75, -67.5, 0)} CharImp=Zpi}} Impedance=50ohm
  P244: Lumped Port Objects=PortSheet_244 LumpedPortType=Modal Modes{Mode1{IntLine{(112.25, -52.5, 0) -> (112.75, -52.5, 0)} CharImp=Zpi}} Impedance=50ohm
  P245: Lumped Port Objects=PortSheet_245 LumpedPortType=Modal Modes{Mode1{IntLine{(112.25, -37.5, 0) -> (112.75, -37.5, 0)} CharImp=Zpi}} Impedance=50ohm
  P246: Lumped Port Objects=PortSheet_246 LumpedPortType=Modal Modes{Mode1{IntLine{(112.25, -22.5, 0) -> (112.75, -22.5, 0)} CharImp=Zpi}} Impedance=50ohm
  P247: Lumped Port Objects=PortSheet_247 LumpedPortType=Modal Modes{Mode1{IntLine{(112.25, -7.5, 0) -> (112.75, -7.5, 0)} CharImp=Zpi}} Impedance=50ohm
  P248: Lumped Port Objects=PortSheet_248 LumpedPortType=Modal Modes{Mode1{IntLine{(112.25, 7.5, 0) -> (112.75, 7.5, 0)} CharImp=Zpi}} Impedance=50ohm
  P249: Lumped Port Objects=PortSheet_249 LumpedPortType=Modal Modes{Mode1{IntLine{(112.25, 22.5, 0) -> (112.75, 22.5, 0)} CharImp=Zpi}} Impedance=50ohm
  P250: Lumped Port Objects=PortSheet_250 LumpedPortType=Modal Modes{Mode1{IntLine{(112.25, 37.5, 0) -> (112.75, 37.5, 0)} CharImp=Zpi}} Impedance=50ohm
  P251: Lumped Port Objects=PortSheet_251 LumpedPortType=Modal Modes{Mode1{IntLine{(112.25, 52.5, 0) -> (112.75, 52.5, 0)} CharImp=Zpi}} Impedance=50ohm
  P252: Lumped Port Objects=PortSheet_252 LumpedPortType=Modal Modes{Mode1{IntLine{(112.25, 67.5, 0) -> (112.75, 67.5, 0)} CharImp=Zpi}} Impedance=50ohm
  P253: Lumped Port Objects=PortSheet_253 LumpedPortType=Modal Modes{Mode1{IntLine{(112.25, 82.5, 0) -> (112.75, 82.5, 0)} CharImp=Zpi}} Impedance=50ohm
  P254: Lumped Port Objects=PortSheet_254 LumpedPortType=Modal Modes{Mode1{IntLine{(112.25, 97.5, 0) -> (112.75, 97.5, 0)} CharImp=Zpi}} Impedance=50ohm
  P255: Lumped Port Objects=PortSheet_255 LumpedPortType=Modal Modes{Mode1{IntLine{(112.25, 112.5, 0) -> (112.75, 112.5, 0)} CharImp=Zpi}} Impedance=50ohm
setups:
  Setup_10GHz: HfssDriven Frequency=10GHz MaxDeltaS=0.05 MaximumPasses=4 MinimumPasses=1 MinimumConvergedPasses=1 PercentRefinement=20 BasisOrder=1 PortAccuracy=2 DrivenSolverType="Direct Solver"
source amplitudes:
  P000:1: 1W 0deg
  P001:1, P002:1, P003:1, P004:1, P005:1, P006:1, P007:1, P008:1, P009:1, P010:1, P011:1, P012:1, P013:1, P014:1, P015:1, P016:1, P017:1, P018:1, P019:1, P020:1, P021:1, P022:1, P023:1, P024:1, P025:1, P026:1, P027:1, P028:1, P029:1, P030:1, P031:1, P032:1, P033:1, P034:1, P035:1, P036:1, P037:1, P038:1, P039:1, P040:1, P041:1, P042:1, P043:1, P044:1, P045:1, P046:1, P047:1, P048:1, P049:1, P050:1, P051:1, P052:1, P053:1, P054:1, P055:1, P056:1, P057:1, P058:1, P059:1, P060:1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: 0W 0deg
radiation setups:
  InfiniteSphere_Theta0_90_Phi0_360: Infinite Sphere Theta=0deg..90deg step 1deg Phi=0deg..360deg step 2deg
